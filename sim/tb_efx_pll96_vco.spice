** sch_path: /home/ejf/Projects/sky130_efx_ip__pll96/xschem/tb_efx_pll96_vco.sch

* Copyright (c) Eric Fogleman 2025
* SPDX-License-Identifier: Apache-2.0

**.subckt tb_efx_pll96_vco
V_VDD vdd GND {VDD}
C1 vcop 0 {CP} m=1
C2 vcon 0 {CP} m=1
V3 net1 GND {VC} PWL(0 0 1n {VC})
xvco vdd_vco vc vdd vcop vcon GND tst_lo tst_mid tst_hi en efx_pll96_vco
V_VDD_VCO vdd_vco GND {VDD}
V42 tst_lo GND {VTLO}
V44 tst_mid GND {VTMID}
V46 tst_hi GND {VTHI}
R1 vc net1 {RC} m=1
V2 en GND {VEN}
**** begin user architecture code

* ejf_delaycell test
.lib ~/.ciel/sky130A/libs.tech/combined/sky130.lib.spice tt
.option temp=27
.param VDD=1.8
.param I_PULSE=1u
.param I_SRC=101u
.param CP=20f
.param VC=0.75
.param VTLO=0
.param VTMID=0
.param VTHI=0
.param VEN=1.8
.param RC=1

* Run transient
* default reltol=1e-3 vntol=1e-6 abstol=1e-12
.options  reltol=1e-6 vntol=1e-9 abstol=1e-15
.control
   save all
   tran 1n 300n
   write tb_efx_pll96_vco.raw
   plot vcop vcon
   meas tran i_v_vdd_avg avg i(v_vdd) from=10n to=100n
   meas tran i_v_vdd_vco_avg avg i(v_vdd_vco) from=10n to=100n
   meas tran vhi_avg avg xvco.vhi from=10n to=100n
   meas tran delta_t trig vcop val=0.5 rise=20 targ vcop val=0.5 rise=21
   print 1/delta_t
.endc
.end

* lvdig standard cells (layout-extracted, C parasitics; symbols are primitives)
.include /home/ejf/Projects/sky130_efx_ip__pll96/dependencies/sky130_efx_ip__lvdig/spice/sky130_efx_lvdig_c.spice

**** end user architecture code
**.ends

* expanding   symbol:  efx_pll96_vco.sym # of pins=10
** sym_path: /home/ejf/Projects/sky130_efx_ip__pll96/xschem/efx_pll96_vco.sym
** sch_path: /home/ejf/Projects/sky130_efx_ip__pll96/xschem/efx_pll96_vco.sch
.subckt efx_pll96_vco vdd_vco vc vdd outp outn gnd_vco tst[0] tst[1] tst[2] en
*.ipin vc
*.iopin vdd_vco
*.opin outp
*.iopin gnd_vco
*.iopin vdd
*.opin outn
*.ipin tst[2]
*.ipin tst[1]
*.ipin tst[0]
*.ipin en
x1 vhi x1p x1n x0n x0p gnd_vco vdd_vco efx_pll96_vco_dlycell
x2 vhi x2n x2p x1p x1n gnd_vco vdd_vco efx_pll96_vco_dlycell
x0 vhi x0n x0p x3n x3p gnd_vco vdd_vco efx_pll96_vco_dlycell
x3 vhi x3p x3n x2n x2p gnd_vco vdd_vco efx_pll96_vco_dlycell
xls vdd x3p outp outn x3n gnd_vco efx_pll96_vco_ls
XMP1[5] vhi vc rd3m[5] vdd_vco sky130_fd_pr__pfet_01v8_lvt L=2.38 W=23.76 nf=4 ad='int((nf+1)/2) * W/nf * 0.29' as='int((nf+2)/2) * W/nf * 0.29'
+ pd='2*int((nf+1)/2) * (W/nf + 0.29)' ps='2*int((nf+2)/2) * (W/nf + 0.29)' nrd='0.29 / W' nrs='0.29 / W' sa=0 sb=0 sd=0 mult=2 m=2
XMP1[4] vhi vc rd3m[4] vdd_vco sky130_fd_pr__pfet_01v8_lvt L=2.38 W=23.76 nf=4 ad='int((nf+1)/2) * W/nf * 0.29' as='int((nf+2)/2) * W/nf * 0.29'
+ pd='2*int((nf+1)/2) * (W/nf + 0.29)' ps='2*int((nf+2)/2) * (W/nf + 0.29)' nrd='0.29 / W' nrs='0.29 / W' sa=0 sb=0 sd=0 mult=2 m=2
XMP1[3] vhi vc rd3m[3] vdd_vco sky130_fd_pr__pfet_01v8_lvt L=2.38 W=23.76 nf=4 ad='int((nf+1)/2) * W/nf * 0.29' as='int((nf+2)/2) * W/nf * 0.29'
+ pd='2*int((nf+1)/2) * (W/nf + 0.29)' ps='2*int((nf+2)/2) * (W/nf + 0.29)' nrd='0.29 / W' nrs='0.29 / W' sa=0 sb=0 sd=0 mult=2 m=2
XMP1[2] vhi vc rd3m[2] vdd_vco sky130_fd_pr__pfet_01v8_lvt L=2.38 W=23.76 nf=4 ad='int((nf+1)/2) * W/nf * 0.29' as='int((nf+2)/2) * W/nf * 0.29'
+ pd='2*int((nf+1)/2) * (W/nf + 0.29)' ps='2*int((nf+2)/2) * (W/nf + 0.29)' nrd='0.29 / W' nrs='0.29 / W' sa=0 sb=0 sd=0 mult=2 m=2
XMP1[1] vhi vc rd3m[1] vdd_vco sky130_fd_pr__pfet_01v8_lvt L=2.38 W=23.76 nf=4 ad='int((nf+1)/2) * W/nf * 0.29' as='int((nf+2)/2) * W/nf * 0.29'
+ pd='2*int((nf+1)/2) * (W/nf + 0.29)' ps='2*int((nf+2)/2) * (W/nf + 0.29)' nrd='0.29 / W' nrs='0.29 / W' sa=0 sb=0 sd=0 mult=2 m=2
XMP1[0] vhi vc rd3m[0] vdd_vco sky130_fd_pr__pfet_01v8_lvt L=2.38 W=23.76 nf=4 ad='int((nf+1)/2) * W/nf * 0.29' as='int((nf+2)/2) * W/nf * 0.29'
+ pd='2*int((nf+1)/2) * (W/nf + 0.29)' ps='2*int((nf+2)/2) * (W/nf + 0.29)' nrd='0.29 / W' nrs='0.29 / W' sa=0 sb=0 sd=0 mult=2 m=2
XM2 net1 tst_bb[1] gnd_vco gnd sky130_fd_pr__nfet_01v8 L=0.15 W=1.08 nf=1 ad='int((nf+1)/2) * W/nf * 0.29' as='int((nf+2)/2) * W/nf * 0.29'
+ pd='2*int((nf+1)/2) * (W/nf + 0.29)' ps='2*int((nf+2)/2) * (W/nf + 0.29)' nrd='0.29 / W' nrs='0.29 / W' sa=0 sb=0 sd=0 mult=1 m=1
XM3 net3 tst_b[0] vdd_vco vdd sky130_fd_pr__pfet_01v8_hvt L=0.15 W=1.98 nf=1 ad='int((nf+1)/2) * W/nf * 0.29' as='int((nf+2)/2) * W/nf * 0.29'
+ pd='2*int((nf+1)/2) * (W/nf + 0.29)' ps='2*int((nf+2)/2) * (W/nf + 0.29)' nrd='0.29 / W' nrs='0.29 / W' sa=0 sb=0 sd=0 mult=1 m=1
XM4 net2 tst_b[2] vdd_vco vdd sky130_fd_pr__pfet_01v8_hvt L=0.15 W=1.98 nf=1 ad='int((nf+1)/2) * W/nf * 0.29' as='int((nf+2)/2) * W/nf * 0.29'
+ pd='2*int((nf+1)/2) * (W/nf + 0.29)' ps='2*int((nf+2)/2) * (W/nf + 0.29)' nrd='0.29 / W' nrs='0.29 / W' sa=0 sb=0 sd=0 mult=1 m=1
XM5 net1 tst_bb[0] gnd_vco gnd sky130_fd_pr__nfet_01v8 L=0.15 W=1.08 nf=1 ad='int((nf+1)/2) * W/nf * 0.29' as='int((nf+2)/2) * W/nf * 0.29'
+ pd='2*int((nf+1)/2) * (W/nf + 0.29)' ps='2*int((nf+2)/2) * (W/nf + 0.29)' nrd='0.29 / W' nrs='0.29 / W' sa=0 sb=0 sd=0 mult=1 m=1
xbuf[2] vdd_vco tst[2] tst_bb[2] tst_b[2] gnd_vco efx_pll96_dbuf
xbuf[1] vdd_vco tst[1] tst_bb[1] tst_b[1] gnd_vco efx_pll96_dbuf
xbuf[0] vdd_vco tst[0] tst_bb[0] tst_b[0] gnd_vco efx_pll96_dbuf
XR4 net6 net7 vdd_vco sky130_fd_pr__res_high_po_0p35 L=9 mult=1 m=1
XR3 net1 net7 vdd_vco sky130_fd_pr__res_high_po_0p35 L=9 mult=1 m=1
XR5 net6 vc vdd_vco sky130_fd_pr__res_high_po_0p35 L=9 mult=1 m=1
XR6 vc net5 vdd_vco sky130_fd_pr__res_high_po_0p35 L=9 mult=1 m=1
XR7 net4 net5 vdd_vco sky130_fd_pr__res_high_po_0p35 L=9 mult=1 m=1
XR8 net4 net2 vdd_vco sky130_fd_pr__res_high_po_0p35 L=9 mult=1 m=1
XR9 net3 net2 vdd_vco sky130_fd_pr__res_high_po_0p35 L=9 mult=1 m=1
**** begin user architecture code

* Copyright (c) Eric Fogleman 2025
* SPDX-License-Identifier: Apache-2.0

**** end user architecture code
* noconn tst_bb[2]
* noconn tst_b[1]
x4 en en_bb gnd_vco gnd_vco vdd_vco vdd_vco sky130_efx_lvdig__buf_1
XM6 net3 en_bb vdd_vco vdd sky130_fd_pr__pfet_01v8_hvt L=0.15 W=1.98 nf=1 ad='int((nf+1)/2) * W/nf * 0.29' as='int((nf+2)/2) * W/nf * 0.29'
+ pd='2*int((nf+1)/2) * (W/nf + 0.29)' ps='2*int((nf+2)/2) * (W/nf + 0.29)' nrd='0.29 / W' nrs='0.29 / W' sa=0 sb=0 sd=0 mult=1 m=1
XRD1[5] rd1m[5] rd0m[5] vdd_vco sky130_fd_pr__res_high_po_0p69 L=6.84 mult=1 m=1
XRD1[4] rd1m[4] rd0m[4] vdd_vco sky130_fd_pr__res_high_po_0p69 L=6.84 mult=1 m=1
XRD1[3] rd1m[3] rd0m[3] vdd_vco sky130_fd_pr__res_high_po_0p69 L=6.84 mult=1 m=1
XRD1[2] rd1m[2] rd0m[2] vdd_vco sky130_fd_pr__res_high_po_0p69 L=6.84 mult=1 m=1
XRD1[1] rd1m[1] rd0m[1] vdd_vco sky130_fd_pr__res_high_po_0p69 L=6.84 mult=1 m=1
XRD1[0] rd1m[0] rd0m[0] vdd_vco sky130_fd_pr__res_high_po_0p69 L=6.84 mult=1 m=1
XRD2[5] rd2m[5] rd1m[5] vdd_vco sky130_fd_pr__res_high_po_0p69 L=6.84 mult=1 m=1
XRD2[4] rd2m[4] rd1m[4] vdd_vco sky130_fd_pr__res_high_po_0p69 L=6.84 mult=1 m=1
XRD2[3] rd2m[3] rd1m[3] vdd_vco sky130_fd_pr__res_high_po_0p69 L=6.84 mult=1 m=1
XRD2[2] rd2m[2] rd1m[2] vdd_vco sky130_fd_pr__res_high_po_0p69 L=6.84 mult=1 m=1
XRD2[1] rd2m[1] rd1m[1] vdd_vco sky130_fd_pr__res_high_po_0p69 L=6.84 mult=1 m=1
XRD2[0] rd2m[0] rd1m[0] vdd_vco sky130_fd_pr__res_high_po_0p69 L=6.84 mult=1 m=1
XRD3[5] rd3m[5] rd2m[5] vdd_vco sky130_fd_pr__res_high_po_0p69 L=6.84 mult=1 m=1
XRD3[4] rd3m[4] rd2m[4] vdd_vco sky130_fd_pr__res_high_po_0p69 L=6.84 mult=1 m=1
XRD3[3] rd3m[3] rd2m[3] vdd_vco sky130_fd_pr__res_high_po_0p69 L=6.84 mult=1 m=1
XRD3[2] rd3m[2] rd2m[2] vdd_vco sky130_fd_pr__res_high_po_0p69 L=6.84 mult=1 m=1
XRD3[1] rd3m[1] rd2m[1] vdd_vco sky130_fd_pr__res_high_po_0p69 L=6.84 mult=1 m=1
XRD3[0] rd3m[0] rd2m[0] vdd_vco sky130_fd_pr__res_high_po_0p69 L=6.84 mult=1 m=1
XRD0[5] vdd_vco rd0m[5] vdd_vco sky130_fd_pr__res_high_po_0p69 L=6.84 mult=1 m=1
XRD0[4] vdd_vco rd0m[4] vdd_vco sky130_fd_pr__res_high_po_0p69 L=6.84 mult=1 m=1
XRD0[3] vdd_vco rd0m[3] vdd_vco sky130_fd_pr__res_high_po_0p69 L=6.84 mult=1 m=1
XRD0[2] vdd_vco rd0m[2] vdd_vco sky130_fd_pr__res_high_po_0p69 L=6.84 mult=1 m=1
XRD0[1] vdd_vco rd0m[1] vdd_vco sky130_fd_pr__res_high_po_0p69 L=6.84 mult=1 m=1
XRD0[0] vdd_vco rd0m[0] vdd_vco sky130_fd_pr__res_high_po_0p69 L=6.84 mult=1 m=1
.ends

* expanding   symbol:  efx_pll96_vco_dlycell.sym # of pins=7
** sym_path: /home/ejf/Projects/sky130_efx_ip__pll96/xschem/efx_pll96_vco_dlycell.sym
** sch_path: /home/ejf/Projects/sky130_efx_ip__pll96/xschem/efx_pll96_vco_dlycell.sch
.subckt efx_pll96_vco_dlycell vhi outn outp inp inn gnd vdd
*.ipin inp
*.opin outn
*.ipin inn
*.opin outp
*.iopin vhi
*.iopin gnd
*.iopin vdd
XMN2P outp outn gnd gnd sky130_fd_pr__nfet_01v8 L=0.44 W=1.26 nf=1 ad='int((nf+1)/2) * W/nf * 0.29' as='int((nf+2)/2) * W/nf * 0.29'
+ pd='2*int((nf+1)/2) * (W/nf + 0.29)' ps='2*int((nf+2)/2) * (W/nf + 0.29)' nrd='0.29 / W' nrs='0.29 / W' sa=0 sb=0 sd=0 mult=1 m=1
XMN1P outn inp gnd gnd sky130_fd_pr__nfet_01v8 L=0.44 W=5.04 nf=4 ad='int((nf+1)/2) * W/nf * 0.29' as='int((nf+2)/2) * W/nf * 0.29'
+ pd='2*int((nf+1)/2) * (W/nf + 0.29)' ps='2*int((nf+2)/2) * (W/nf + 0.29)' nrd='0.29 / W' nrs='0.29 / W' sa=0 sb=0 sd=0 mult=1 m=1
XMP1P outn inp vhi vdd sky130_fd_pr__pfet_01v8_hvt L=0.44 W=19.44 nf=4 ad='int((nf+1)/2) * W/nf * 0.29' as='int((nf+2)/2) * W/nf * 0.29'
+ pd='2*int((nf+1)/2) * (W/nf + 0.29)' ps='2*int((nf+2)/2) * (W/nf + 0.29)' nrd='0.29 / W' nrs='0.29 / W' sa=0 sb=0 sd=0 mult=1 m=1
XMN2N outn outp gnd gnd sky130_fd_pr__nfet_01v8 L=0.44 W=1.26 nf=1 ad='int((nf+1)/2) * W/nf * 0.29' as='int((nf+2)/2) * W/nf * 0.29'
+ pd='2*int((nf+1)/2) * (W/nf + 0.29)' ps='2*int((nf+2)/2) * (W/nf + 0.29)' nrd='0.29 / W' nrs='0.29 / W' sa=0 sb=0 sd=0 mult=1 m=1
XMN1N outp inn gnd gnd sky130_fd_pr__nfet_01v8 L=0.44 W=5.04 nf=4 ad='int((nf+1)/2) * W/nf * 0.29' as='int((nf+2)/2) * W/nf * 0.29'
+ pd='2*int((nf+1)/2) * (W/nf + 0.29)' ps='2*int((nf+2)/2) * (W/nf + 0.29)' nrd='0.29 / W' nrs='0.29 / W' sa=0 sb=0 sd=0 mult=1 m=1
XMP1N outp inn vhi vdd sky130_fd_pr__pfet_01v8_hvt L=0.44 W=19.44 nf=4 ad='int((nf+1)/2) * W/nf * 0.29' as='int((nf+2)/2) * W/nf * 0.29'
+ pd='2*int((nf+1)/2) * (W/nf + 0.29)' ps='2*int((nf+2)/2) * (W/nf + 0.29)' nrd='0.29 / W' nrs='0.29 / W' sa=0 sb=0 sd=0 mult=1 m=1
**** begin user architecture code

* Copyright (c) Eric Fogleman 2025
* SPDX-License-Identifier: Apache-2.0

**** end user architecture code
XMND1 outn gnd gnd gnd sky130_fd_pr__nfet_01v8 L=0.44 W=1.26 nf=1 ad='int((nf+1)/2) * W/nf * 0.29' as='int((nf+2)/2) * W/nf * 0.29'
+ pd='2*int((nf+1)/2) * (W/nf + 0.29)' ps='2*int((nf+2)/2) * (W/nf + 0.29)' nrd='0.29 / W' nrs='0.29 / W' sa=0 sb=0 sd=0 mult=1 m=1
XMPD1[1] vhi vhi vhi vdd sky130_fd_pr__pfet_01v8_hvt L=0.44 W=4.86 nf=1 ad='int((nf+1)/2) * W/nf * 0.29' as='int((nf+2)/2) * W/nf * 0.29'
+ pd='2*int((nf+1)/2) * (W/nf + 0.29)' ps='2*int((nf+2)/2) * (W/nf + 0.29)' nrd='0.29 / W' nrs='0.29 / W' sa=0 sb=0 sd=0 mult=1 m=1
XMPD1[0] vhi vhi vhi vdd sky130_fd_pr__pfet_01v8_hvt L=0.44 W=4.86 nf=1 ad='int((nf+1)/2) * W/nf * 0.29' as='int((nf+2)/2) * W/nf * 0.29'
+ pd='2*int((nf+1)/2) * (W/nf + 0.29)' ps='2*int((nf+2)/2) * (W/nf + 0.29)' nrd='0.29 / W' nrs='0.29 / W' sa=0 sb=0 sd=0 mult=1 m=1
XMND2 outp gnd gnd gnd sky130_fd_pr__nfet_01v8 L=0.44 W=1.26 nf=1 ad='int((nf+1)/2) * W/nf * 0.29' as='int((nf+2)/2) * W/nf * 0.29'
+ pd='2*int((nf+1)/2) * (W/nf + 0.29)' ps='2*int((nf+2)/2) * (W/nf + 0.29)' nrd='0.29 / W' nrs='0.29 / W' sa=0 sb=0 sd=0 mult=1 m=1
CP0 inn inp 0.18f m=1
CP1 inp vdd 0.26f m=1
CP2 inp outn 1.63f m=1
CP3 vhi inp 0.61f m=1
CP4 inn vdd 0.26f m=1
CP5 inn outn 0.14f m=1
CP6 inp outp 0.20f m=1
CP7 inn vhi 0.62f m=1
CP8 inn outp 1.71f m=1
CP9 vdd outn 0.74f m=1
CP10 vhi vdd 2.24f m=1
CP11 vhi outn 1.46f m=1
CP12 vdd outp 0.33f m=1
CP13 outp outn 1.73f m=1
CP14 vhi outp 1.51f m=1
CP15 outp gnd 1.38f m=1
CP16 outn gnd 1.40f m=1
CP17 inn gnd 1.41f m=1
CP18 inp gnd 1.43f m=1
CP19 vhi gnd 1.58f m=1
CP20 vdd gnd 7.34f m=1
.ends

* expanding   symbol:  efx_pll96_vco_ls.sym # of pins=6
** sym_path: /home/ejf/Projects/sky130_efx_ip__pll96/xschem/efx_pll96_vco_ls.sym
** sch_path: /home/ejf/Projects/sky130_efx_ip__pll96/xschem/efx_pll96_vco_ls.sch
.subckt efx_pll96_vco_ls vdd inp outp outn inn gnd
*.ipin inp
*.opin outn
*.ipin inn
*.opin outp
*.iopin vdd
*.iopin gnd
XM5 net1 ls_outn vdd vdd sky130_fd_pr__pfet_01v8_hvt L=0.15 W=1.08 nf=1 ad='int((nf+1)/2) * W/nf * 0.29' as='int((nf+2)/2) * W/nf * 0.29'
+ pd='2*int((nf+1)/2) * (W/nf + 0.29)' ps='2*int((nf+2)/2) * (W/nf + 0.29)' nrd='0.29 / W' nrs='0.29 / W' sa=0 sb=0 sd=0 mult=2 m=2
XM1 ls_outn inp gnd gnd sky130_fd_pr__nfet_01v8 L=0.15 W=0.54 nf=1 ad='int((nf+1)/2) * W/nf * 0.29' as='int((nf+2)/2) * W/nf * 0.29'
+ pd='2*int((nf+1)/2) * (W/nf + 0.29)' ps='2*int((nf+2)/2) * (W/nf + 0.29)' nrd='0.29 / W' nrs='0.29 / W' sa=0 sb=0 sd=0 mult=4 m=4
XM2 ls_outp inn gnd gnd sky130_fd_pr__nfet_01v8 L=0.15 W=0.54 nf=1 ad='int((nf+1)/2) * W/nf * 0.29' as='int((nf+2)/2) * W/nf * 0.29'
+ pd='2*int((nf+1)/2) * (W/nf + 0.29)' ps='2*int((nf+2)/2) * (W/nf + 0.29)' nrd='0.29 / W' nrs='0.29 / W' sa=0 sb=0 sd=0 mult=4 m=4
XM3 net2 ls_outp vdd vdd sky130_fd_pr__pfet_01v8_hvt L=0.15 W=1.08 nf=1 ad='int((nf+1)/2) * W/nf * 0.29' as='int((nf+2)/2) * W/nf * 0.29'
+ pd='2*int((nf+1)/2) * (W/nf + 0.29)' ps='2*int((nf+2)/2) * (W/nf + 0.29)' nrd='0.29 / W' nrs='0.29 / W' sa=0 sb=0 sd=0 mult=2 m=2
XM4 ls_outn inp net2 vdd sky130_fd_pr__pfet_01v8_hvt L=0.15 W=1.08 nf=1 ad='int((nf+1)/2) * W/nf * 0.29' as='int((nf+2)/2) * W/nf * 0.29'
+ pd='2*int((nf+1)/2) * (W/nf + 0.29)' ps='2*int((nf+2)/2) * (W/nf + 0.29)' nrd='0.29 / W' nrs='0.29 / W' sa=0 sb=0 sd=0 mult=2 m=2
XM6 ls_outp inn net1 vdd sky130_fd_pr__pfet_01v8_hvt L=0.15 W=1.08 nf=1 ad='int((nf+1)/2) * W/nf * 0.29' as='int((nf+2)/2) * W/nf * 0.29'
+ pd='2*int((nf+1)/2) * (W/nf + 0.29)' ps='2*int((nf+2)/2) * (W/nf + 0.29)' nrd='0.29 / W' nrs='0.29 / W' sa=0 sb=0 sd=0 mult=2 m=2
XM7 outn ls_outp gnd gnd sky130_fd_pr__nfet_01v8 L=0.15 W=0.54 nf=1 ad='int((nf+1)/2) * W/nf * 0.29' as='int((nf+2)/2) * W/nf * 0.29'
+ pd='2*int((nf+1)/2) * (W/nf + 0.29)' ps='2*int((nf+2)/2) * (W/nf + 0.29)' nrd='0.29 / W' nrs='0.29 / W' sa=0 sb=0 sd=0 mult=4 m=4
XM8 outn ls_outp vdd vdd sky130_fd_pr__pfet_01v8_hvt L=0.15 W=3.96 nf=1 ad='int((nf+1)/2) * W/nf * 0.29' as='int((nf+2)/2) * W/nf * 0.29'
+ pd='2*int((nf+1)/2) * (W/nf + 0.29)' ps='2*int((nf+2)/2) * (W/nf + 0.29)' nrd='0.29 / W' nrs='0.29 / W' sa=0 sb=0 sd=0 mult=1 m=1
XM9 outp ls_outn gnd gnd sky130_fd_pr__nfet_01v8 L=0.15 W=0.54 nf=1 ad='int((nf+1)/2) * W/nf * 0.29' as='int((nf+2)/2) * W/nf * 0.29'
+ pd='2*int((nf+1)/2) * (W/nf + 0.29)' ps='2*int((nf+2)/2) * (W/nf + 0.29)' nrd='0.29 / W' nrs='0.29 / W' sa=0 sb=0 sd=0 mult=4 m=4
XM10 outp ls_outn vdd vdd sky130_fd_pr__pfet_01v8_hvt L=0.15 W=1.08 nf=1 ad='int((nf+1)/2) * W/nf * 0.29' as='int((nf+2)/2) * W/nf * 0.29'
+ pd='2*int((nf+1)/2) * (W/nf + 0.29)' ps='2*int((nf+2)/2) * (W/nf + 0.29)' nrd='0.29 / W' nrs='0.29 / W' sa=0 sb=0 sd=0 mult=4 m=4
**** begin user architecture code

* Copyright (c) Eric Fogleman 2025
* SPDX-License-Identifier: Apache-2.0

**** end user architecture code
.ends

* expanding   symbol:  efx_pll96_dbuf.sym # of pins=5
** sym_path: /home/ejf/Projects/sky130_efx_ip__pll96/xschem/efx_pll96_dbuf.sym
** sch_path: /home/ejf/Projects/sky130_efx_ip__pll96/xschem/efx_pll96_dbuf.sch
.subckt efx_pll96_dbuf vdd a y y_b gnd
*.ipin a
*.iopin vdd
*.iopin gnd
*.opin y
*.opin y_b
**** begin user architecture code

* Copyright (c) Eric Fogleman 2025
* SPDX-License-Identifier: Apache-2.0

**** end user architecture code
x1 a y_b gnd gnd vdd vdd sky130_efx_lvdig__inv_1
x2 y_b y gnd gnd vdd vdd sky130_efx_lvdig__inv_1
.ends

.GLOBAL GND
.end
