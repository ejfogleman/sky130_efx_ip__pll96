** EFX_PLL96_CHP flat netlist
*.IOPIN VDD
*.IOPIN GND
*.IOPIN IBNP_1U
*.IOPIN VC
*.IPIN P
*.IPIN N_B
*.IPIN P_B
*.IPIN N
*.IPIN EN
*.IPIN B[2]
*.IPIN B[1]
*.IPIN B[0]
*.IPIN VC2
*--------BEGIN_XMP2_2[1]->SKY130_FD_PR__PFET_01V8_LVT
XMP2_2[1] MP2D MP2_2G VDD VDD  SKY130_FD_PR__PFET_01V8_LVT L=1.2 W=0.6 NF=1 AD='INT((NF+1)/2)*W/NF*0.29' AS='INT((NF+2)/2)*W/NF*0.29'
+ PD='2*INT((NF+1)/2)*(W/NF+0.29)' PS='2*INT((NF+2)/2)*(W/NF+0.29)' NRD='0.29/W' NRS='0.29/W' SA=0 SB=0 SD=0 MULT=1 M=1
*--------END___XMP2_2[1]->SKY130_FD_PR__PFET_01V8_LVT
*--------BEGIN_XMP2_2[0]->SKY130_FD_PR__PFET_01V8_LVT
XMP2_2[0] MP2D MP2_2G VDD VDD  SKY130_FD_PR__PFET_01V8_LVT L=1.2 W=0.6 NF=1 AD='INT((NF+1)/2)*W/NF*0.29' AS='INT((NF+2)/2)*W/NF*0.29'
+ PD='2*INT((NF+1)/2)*(W/NF+0.29)' PS='2*INT((NF+2)/2)*(W/NF+0.29)' NRD='0.29/W' NRS='0.29/W' SA=0 SB=0 SD=0 MULT=1 M=1
*--------END___XMP2_2[0]->SKY130_FD_PR__PFET_01V8_LVT
*--------BEGIN_XMN3->SKY130_FD_PR__NFET_01V8
XMN3 NET1 MN1G GND GND  SKY130_FD_PR__NFET_01V8 L=1.2 W=0.6 NF=1 AD='INT((NF+1)/2)*W/NF*0.29' AS='INT((NF+2)/2)*W/NF*0.29' PD='2*INT((NF+1)/2)*(W/NF+0.29)'
+ PS='2*INT((NF+2)/2)*(W/NF+0.29)' NRD='0.29/W' NRS='0.29/W' SA=0 SB=0 SD=0 MULT=1 M=1
*--------END___XMN3->SKY130_FD_PR__NFET_01V8
*--------BEGIN_XMN3C->SKY130_FD_PR__NFET_01V8
XMN3C MN1G MN1CG NET1 GND  SKY130_FD_PR__NFET_01V8 L=0.3 W=0.6 NF=1 AD='INT((NF+1)/2)*W/NF*0.29' AS='INT((NF+2)/2)*W/NF*0.29' PD='2*INT((NF+1)/2)*(W/NF+0.29)'
+ PS='2*INT((NF+2)/2)*(W/NF+0.29)' NRD='0.29/W' NRS='0.29/W' SA=0 SB=0 SD=0 MULT=1 M=1
*--------END___XMN3C->SKY130_FD_PR__NFET_01V8
*--------BEGIN_XMP1[14]->SKY130_FD_PR__PFET_01V8_LVT
XMP1[14] MP1D MP1G VDD VDD  SKY130_FD_PR__PFET_01V8_LVT L=1.2 W=0.6 NF=1 AD='INT((NF+1)/2)*W/NF*0.29' AS='INT((NF+2)/2)*W/NF*0.29'
+ PD='2*INT((NF+1)/2)*(W/NF+0.29)' PS='2*INT((NF+2)/2)*(W/NF+0.29)' NRD='0.29/W' NRS='0.29/W' SA=0 SB=0 SD=0 MULT=1 M=1
*--------END___XMP1[14]->SKY130_FD_PR__PFET_01V8_LVT
*--------BEGIN_XMP1[13]->SKY130_FD_PR__PFET_01V8_LVT
XMP1[13] MP1D MP1G VDD VDD  SKY130_FD_PR__PFET_01V8_LVT L=1.2 W=0.6 NF=1 AD='INT((NF+1)/2)*W/NF*0.29' AS='INT((NF+2)/2)*W/NF*0.29'
+ PD='2*INT((NF+1)/2)*(W/NF+0.29)' PS='2*INT((NF+2)/2)*(W/NF+0.29)' NRD='0.29/W' NRS='0.29/W' SA=0 SB=0 SD=0 MULT=1 M=1
*--------END___XMP1[13]->SKY130_FD_PR__PFET_01V8_LVT
*--------BEGIN_XMP1[12]->SKY130_FD_PR__PFET_01V8_LVT
XMP1[12] MP1D MP1G VDD VDD  SKY130_FD_PR__PFET_01V8_LVT L=1.2 W=0.6 NF=1 AD='INT((NF+1)/2)*W/NF*0.29' AS='INT((NF+2)/2)*W/NF*0.29'
+ PD='2*INT((NF+1)/2)*(W/NF+0.29)' PS='2*INT((NF+2)/2)*(W/NF+0.29)' NRD='0.29/W' NRS='0.29/W' SA=0 SB=0 SD=0 MULT=1 M=1
*--------END___XMP1[12]->SKY130_FD_PR__PFET_01V8_LVT
*--------BEGIN_XMP1[11]->SKY130_FD_PR__PFET_01V8_LVT
XMP1[11] MP1D MP1G VDD VDD  SKY130_FD_PR__PFET_01V8_LVT L=1.2 W=0.6 NF=1 AD='INT((NF+1)/2)*W/NF*0.29' AS='INT((NF+2)/2)*W/NF*0.29'
+ PD='2*INT((NF+1)/2)*(W/NF+0.29)' PS='2*INT((NF+2)/2)*(W/NF+0.29)' NRD='0.29/W' NRS='0.29/W' SA=0 SB=0 SD=0 MULT=1 M=1
*--------END___XMP1[11]->SKY130_FD_PR__PFET_01V8_LVT
*--------BEGIN_XMP1[10]->SKY130_FD_PR__PFET_01V8_LVT
XMP1[10] MP1D MP1G VDD VDD  SKY130_FD_PR__PFET_01V8_LVT L=1.2 W=0.6 NF=1 AD='INT((NF+1)/2)*W/NF*0.29' AS='INT((NF+2)/2)*W/NF*0.29'
+ PD='2*INT((NF+1)/2)*(W/NF+0.29)' PS='2*INT((NF+2)/2)*(W/NF+0.29)' NRD='0.29/W' NRS='0.29/W' SA=0 SB=0 SD=0 MULT=1 M=1
*--------END___XMP1[10]->SKY130_FD_PR__PFET_01V8_LVT
*--------BEGIN_XMP1[9]->SKY130_FD_PR__PFET_01V8_LVT
XMP1[9] MP1D MP1G VDD VDD  SKY130_FD_PR__PFET_01V8_LVT L=1.2 W=0.6 NF=1 AD='INT((NF+1)/2)*W/NF*0.29' AS='INT((NF+2)/2)*W/NF*0.29' PD='2*INT((NF+1)/2)*(W/NF+0.29)'
+ PS='2*INT((NF+2)/2)*(W/NF+0.29)' NRD='0.29/W' NRS='0.29/W' SA=0 SB=0 SD=0 MULT=1 M=1
*--------END___XMP1[9]->SKY130_FD_PR__PFET_01V8_LVT
*--------BEGIN_XMP1[8]->SKY130_FD_PR__PFET_01V8_LVT
XMP1[8] MP1D MP1G VDD VDD  SKY130_FD_PR__PFET_01V8_LVT L=1.2 W=0.6 NF=1 AD='INT((NF+1)/2)*W/NF*0.29' AS='INT((NF+2)/2)*W/NF*0.29' PD='2*INT((NF+1)/2)*(W/NF+0.29)'
+ PS='2*INT((NF+2)/2)*(W/NF+0.29)' NRD='0.29/W' NRS='0.29/W' SA=0 SB=0 SD=0 MULT=1 M=1
*--------END___XMP1[8]->SKY130_FD_PR__PFET_01V8_LVT
*--------BEGIN_XMP1[7]->SKY130_FD_PR__PFET_01V8_LVT
XMP1[7] MP1D MP1G VDD VDD  SKY130_FD_PR__PFET_01V8_LVT L=1.2 W=0.6 NF=1 AD='INT((NF+1)/2)*W/NF*0.29' AS='INT((NF+2)/2)*W/NF*0.29' PD='2*INT((NF+1)/2)*(W/NF+0.29)'
+ PS='2*INT((NF+2)/2)*(W/NF+0.29)' NRD='0.29/W' NRS='0.29/W' SA=0 SB=0 SD=0 MULT=1 M=1
*--------END___XMP1[7]->SKY130_FD_PR__PFET_01V8_LVT
*--------BEGIN_XMP1[6]->SKY130_FD_PR__PFET_01V8_LVT
XMP1[6] MP1D MP1G VDD VDD  SKY130_FD_PR__PFET_01V8_LVT L=1.2 W=0.6 NF=1 AD='INT((NF+1)/2)*W/NF*0.29' AS='INT((NF+2)/2)*W/NF*0.29' PD='2*INT((NF+1)/2)*(W/NF+0.29)'
+ PS='2*INT((NF+2)/2)*(W/NF+0.29)' NRD='0.29/W' NRS='0.29/W' SA=0 SB=0 SD=0 MULT=1 M=1
*--------END___XMP1[6]->SKY130_FD_PR__PFET_01V8_LVT
*--------BEGIN_XMP1[5]->SKY130_FD_PR__PFET_01V8_LVT
XMP1[5] MP1D MP1G VDD VDD  SKY130_FD_PR__PFET_01V8_LVT L=1.2 W=0.6 NF=1 AD='INT((NF+1)/2)*W/NF*0.29' AS='INT((NF+2)/2)*W/NF*0.29' PD='2*INT((NF+1)/2)*(W/NF+0.29)'
+ PS='2*INT((NF+2)/2)*(W/NF+0.29)' NRD='0.29/W' NRS='0.29/W' SA=0 SB=0 SD=0 MULT=1 M=1
*--------END___XMP1[5]->SKY130_FD_PR__PFET_01V8_LVT
*--------BEGIN_XMP1[4]->SKY130_FD_PR__PFET_01V8_LVT
XMP1[4] MP1D MP1G VDD VDD  SKY130_FD_PR__PFET_01V8_LVT L=1.2 W=0.6 NF=1 AD='INT((NF+1)/2)*W/NF*0.29' AS='INT((NF+2)/2)*W/NF*0.29' PD='2*INT((NF+1)/2)*(W/NF+0.29)'
+ PS='2*INT((NF+2)/2)*(W/NF+0.29)' NRD='0.29/W' NRS='0.29/W' SA=0 SB=0 SD=0 MULT=1 M=1
*--------END___XMP1[4]->SKY130_FD_PR__PFET_01V8_LVT
*--------BEGIN_XMP1[3]->SKY130_FD_PR__PFET_01V8_LVT
XMP1[3] MP1D MP1G VDD VDD  SKY130_FD_PR__PFET_01V8_LVT L=1.2 W=0.6 NF=1 AD='INT((NF+1)/2)*W/NF*0.29' AS='INT((NF+2)/2)*W/NF*0.29' PD='2*INT((NF+1)/2)*(W/NF+0.29)'
+ PS='2*INT((NF+2)/2)*(W/NF+0.29)' NRD='0.29/W' NRS='0.29/W' SA=0 SB=0 SD=0 MULT=1 M=1
*--------END___XMP1[3]->SKY130_FD_PR__PFET_01V8_LVT
*--------BEGIN_XMP1[2]->SKY130_FD_PR__PFET_01V8_LVT
XMP1[2] MP1D MP1G VDD VDD  SKY130_FD_PR__PFET_01V8_LVT L=1.2 W=0.6 NF=1 AD='INT((NF+1)/2)*W/NF*0.29' AS='INT((NF+2)/2)*W/NF*0.29' PD='2*INT((NF+1)/2)*(W/NF+0.29)'
+ PS='2*INT((NF+2)/2)*(W/NF+0.29)' NRD='0.29/W' NRS='0.29/W' SA=0 SB=0 SD=0 MULT=1 M=1
*--------END___XMP1[2]->SKY130_FD_PR__PFET_01V8_LVT
*--------BEGIN_XMP1[1]->SKY130_FD_PR__PFET_01V8_LVT
XMP1[1] MP1D MP1G VDD VDD  SKY130_FD_PR__PFET_01V8_LVT L=1.2 W=0.6 NF=1 AD='INT((NF+1)/2)*W/NF*0.29' AS='INT((NF+2)/2)*W/NF*0.29' PD='2*INT((NF+1)/2)*(W/NF+0.29)'
+ PS='2*INT((NF+2)/2)*(W/NF+0.29)' NRD='0.29/W' NRS='0.29/W' SA=0 SB=0 SD=0 MULT=1 M=1
*--------END___XMP1[1]->SKY130_FD_PR__PFET_01V8_LVT
*--------BEGIN_XMP1[0]->SKY130_FD_PR__PFET_01V8_LVT
XMP1[0] MP1D MP1G VDD VDD  SKY130_FD_PR__PFET_01V8_LVT L=1.2 W=0.6 NF=1 AD='INT((NF+1)/2)*W/NF*0.29' AS='INT((NF+2)/2)*W/NF*0.29' PD='2*INT((NF+1)/2)*(W/NF+0.29)'
+ PS='2*INT((NF+2)/2)*(W/NF+0.29)' NRD='0.29/W' NRS='0.29/W' SA=0 SB=0 SD=0 MULT=1 M=1
*--------END___XMP1[0]->SKY130_FD_PR__PFET_01V8_LVT
*--------BEGIN_XMP2C->SKY130_FD_PR__PFET_01V8_LVT
XMP2C MP1G IBNP_1U MP2D VDD  SKY130_FD_PR__PFET_01V8_LVT L=0.35 W=1.2 NF=1 AD='INT((NF+1)/2)*W/NF*0.29' AS='INT((NF+2)/2)*W/NF*0.29'
+ PD='2*INT((NF+1)/2)*(W/NF+0.29)' PS='2*INT((NF+2)/2)*(W/NF+0.29)' NRD='0.29/W' NRS='0.29/W' SA=0 SB=0 SD=0 MULT=1 M=1
*--------END___XMP2C->SKY130_FD_PR__PFET_01V8_LVT
*--------BEGIN_XMP1C->SKY130_FD_PR__PFET_01V8_LVT
XMP1C MP1CD IBNP_1U MP1D VDD  SKY130_FD_PR__PFET_01V8_LVT L=0.35 W=6 NF=5 AD='INT((NF+1)/2)*W/NF*0.29' AS='INT((NF+2)/2)*W/NF*0.29'
+ PD='2*INT((NF+1)/2)*(W/NF+0.29)' PS='2*INT((NF+2)/2)*(W/NF+0.29)' NRD='0.29/W' NRS='0.29/W' SA=0 SB=0 SD=0 MULT=1 M=1
*--------END___XMP1C->SKY130_FD_PR__PFET_01V8_LVT
*--------BEGIN_XMN1[4]->SKY130_FD_PR__NFET_01V8
XMN1[4] MN1D MN1G GND GND  SKY130_FD_PR__NFET_01V8 L=1.2 W=0.6 NF=1 AD='INT((NF+1)/2)*W/NF*0.29' AS='INT((NF+2)/2)*W/NF*0.29' PD='2*INT((NF+1)/2)*(W/NF+0.29)'
+ PS='2*INT((NF+2)/2)*(W/NF+0.29)' NRD='0.29/W' NRS='0.29/W' SA=0 SB=0 SD=0 MULT=1 M=1
*--------END___XMN1[4]->SKY130_FD_PR__NFET_01V8
*--------BEGIN_XMN1[3]->SKY130_FD_PR__NFET_01V8
XMN1[3] MN1D MN1G GND GND  SKY130_FD_PR__NFET_01V8 L=1.2 W=0.6 NF=1 AD='INT((NF+1)/2)*W/NF*0.29' AS='INT((NF+2)/2)*W/NF*0.29' PD='2*INT((NF+1)/2)*(W/NF+0.29)'
+ PS='2*INT((NF+2)/2)*(W/NF+0.29)' NRD='0.29/W' NRS='0.29/W' SA=0 SB=0 SD=0 MULT=1 M=1
*--------END___XMN1[3]->SKY130_FD_PR__NFET_01V8
*--------BEGIN_XMN1[2]->SKY130_FD_PR__NFET_01V8
XMN1[2] MN1D MN1G GND GND  SKY130_FD_PR__NFET_01V8 L=1.2 W=0.6 NF=1 AD='INT((NF+1)/2)*W/NF*0.29' AS='INT((NF+2)/2)*W/NF*0.29' PD='2*INT((NF+1)/2)*(W/NF+0.29)'
+ PS='2*INT((NF+2)/2)*(W/NF+0.29)' NRD='0.29/W' NRS='0.29/W' SA=0 SB=0 SD=0 MULT=1 M=1
*--------END___XMN1[2]->SKY130_FD_PR__NFET_01V8
*--------BEGIN_XMN1[1]->SKY130_FD_PR__NFET_01V8
XMN1[1] MN1D MN1G GND GND  SKY130_FD_PR__NFET_01V8 L=1.2 W=0.6 NF=1 AD='INT((NF+1)/2)*W/NF*0.29' AS='INT((NF+2)/2)*W/NF*0.29' PD='2*INT((NF+1)/2)*(W/NF+0.29)'
+ PS='2*INT((NF+2)/2)*(W/NF+0.29)' NRD='0.29/W' NRS='0.29/W' SA=0 SB=0 SD=0 MULT=1 M=1
*--------END___XMN1[1]->SKY130_FD_PR__NFET_01V8
*--------BEGIN_XMN1[0]->SKY130_FD_PR__NFET_01V8
XMN1[0] MN1D MN1G GND GND  SKY130_FD_PR__NFET_01V8 L=1.2 W=0.6 NF=1 AD='INT((NF+1)/2)*W/NF*0.29' AS='INT((NF+2)/2)*W/NF*0.29' PD='2*INT((NF+1)/2)*(W/NF+0.29)'
+ PS='2*INT((NF+2)/2)*(W/NF+0.29)' NRD='0.29/W' NRS='0.29/W' SA=0 SB=0 SD=0 MULT=1 M=1
*--------END___XMN1[0]->SKY130_FD_PR__NFET_01V8
*--------BEGIN_XM1C->SKY130_FD_PR__NFET_01V8
XM1C MN1CD MN1CG MN1D GND  SKY130_FD_PR__NFET_01V8 L=0.3 W=3.0 NF=5 AD='INT((NF+1)/2)*W/NF*0.29' AS='INT((NF+2)/2)*W/NF*0.29' PD='2*INT((NF+1)/2)*(W/NF+0.29)'
+ PS='2*INT((NF+2)/2)*(W/NF+0.29)' NRD='0.29/W' NRS='0.29/W' SA=0 SB=0 SD=0 MULT=1 M=1
*--------END___XM1C->SKY130_FD_PR__NFET_01V8
*--------BEGIN_XMP11->SKY130_FD_PR__PFET_01V8
XMP11 VC_REPL P MP1CD VDD  SKY130_FD_PR__PFET_01V8 L=0.15 W=1 NF=1 AD='INT((NF+1)/2)*W/NF*0.29' AS='INT((NF+2)/2)*W/NF*0.29' PD='2*INT((NF+1)/2)*(W/NF+0.29)'
+ PS='2*INT((NF+2)/2)*(W/NF+0.29)' NRD='0.29/W' NRS='0.29/W' SA=0 SB=0 SD=0 MULT=1 M=1
*--------END___XMP11->SKY130_FD_PR__PFET_01V8
*--------BEGIN_XMN11->SKY130_FD_PR__NFET_01V8
XMN11 VC_REPL N_B MN1CD GND  SKY130_FD_PR__NFET_01V8 L=0.15 W=1 NF=1 AD='INT((NF+1)/2)*W/NF*0.29' AS='INT((NF+2)/2)*W/NF*0.29' PD='2*INT((NF+1)/2)*(W/NF+0.29)'
+ PS='2*INT((NF+2)/2)*(W/NF+0.29)' NRD='0.29/W' NRS='0.29/W' SA=0 SB=0 SD=0 MULT=1 M=1
*--------END___XMN11->SKY130_FD_PR__NFET_01V8
*--------BEGIN_XMP10->SKY130_FD_PR__PFET_01V8
XMP10 VC P_B MP1CD VDD  SKY130_FD_PR__PFET_01V8 L=0.15 W=1 NF=1 AD='INT((NF+1)/2)*W/NF*0.29' AS='INT((NF+2)/2)*W/NF*0.29' PD='2*INT((NF+1)/2)*(W/NF+0.29)'
+ PS='2*INT((NF+2)/2)*(W/NF+0.29)' NRD='0.29/W' NRS='0.29/W' SA=0 SB=0 SD=0 MULT=1 M=1
*--------END___XMP10->SKY130_FD_PR__PFET_01V8
*--------BEGIN_XMN10->SKY130_FD_PR__NFET_01V8
XMN10 VC N MN1CD GND  SKY130_FD_PR__NFET_01V8 L=0.15 W=1 NF=1 AD='INT((NF+1)/2)*W/NF*0.29' AS='INT((NF+2)/2)*W/NF*0.29' PD='2*INT((NF+1)/2)*(W/NF+0.29)'
+ PS='2*INT((NF+2)/2)*(W/NF+0.29)' NRD='0.29/W' NRS='0.29/W' SA=0 SB=0 SD=0 MULT=1 M=1
*--------END___XMN10->SKY130_FD_PR__NFET_01V8
*--------BEGIN_XMP20[5]->SKY130_FD_PR__PFET_01V8_LVT
XMP20[5] MP20D MP1G VDD VDD  SKY130_FD_PR__PFET_01V8_LVT L=1.2 W=0.6 NF=1 AD='INT((NF+1)/2)*W/NF*0.29' AS='INT((NF+2)/2)*W/NF*0.29'
+ PD='2*INT((NF+1)/2)*(W/NF+0.29)' PS='2*INT((NF+2)/2)*(W/NF+0.29)' NRD='0.29/W' NRS='0.29/W' SA=0 SB=0 SD=0 MULT=1 M=1
*--------END___XMP20[5]->SKY130_FD_PR__PFET_01V8_LVT
*--------BEGIN_XMP20[4]->SKY130_FD_PR__PFET_01V8_LVT
XMP20[4] MP20D MP1G VDD VDD  SKY130_FD_PR__PFET_01V8_LVT L=1.2 W=0.6 NF=1 AD='INT((NF+1)/2)*W/NF*0.29' AS='INT((NF+2)/2)*W/NF*0.29'
+ PD='2*INT((NF+1)/2)*(W/NF+0.29)' PS='2*INT((NF+2)/2)*(W/NF+0.29)' NRD='0.29/W' NRS='0.29/W' SA=0 SB=0 SD=0 MULT=1 M=1
*--------END___XMP20[4]->SKY130_FD_PR__PFET_01V8_LVT
*--------BEGIN_XMP20[3]->SKY130_FD_PR__PFET_01V8_LVT
XMP20[3] MP20D MP1G VDD VDD  SKY130_FD_PR__PFET_01V8_LVT L=1.2 W=0.6 NF=1 AD='INT((NF+1)/2)*W/NF*0.29' AS='INT((NF+2)/2)*W/NF*0.29'
+ PD='2*INT((NF+1)/2)*(W/NF+0.29)' PS='2*INT((NF+2)/2)*(W/NF+0.29)' NRD='0.29/W' NRS='0.29/W' SA=0 SB=0 SD=0 MULT=1 M=1
*--------END___XMP20[3]->SKY130_FD_PR__PFET_01V8_LVT
*--------BEGIN_XMP20[2]->SKY130_FD_PR__PFET_01V8_LVT
XMP20[2] MP20D MP1G VDD VDD  SKY130_FD_PR__PFET_01V8_LVT L=1.2 W=0.6 NF=1 AD='INT((NF+1)/2)*W/NF*0.29' AS='INT((NF+2)/2)*W/NF*0.29'
+ PD='2*INT((NF+1)/2)*(W/NF+0.29)' PS='2*INT((NF+2)/2)*(W/NF+0.29)' NRD='0.29/W' NRS='0.29/W' SA=0 SB=0 SD=0 MULT=1 M=1
*--------END___XMP20[2]->SKY130_FD_PR__PFET_01V8_LVT
*--------BEGIN_XMP20[1]->SKY130_FD_PR__PFET_01V8_LVT
XMP20[1] MP20D MP1G VDD VDD  SKY130_FD_PR__PFET_01V8_LVT L=1.2 W=0.6 NF=1 AD='INT((NF+1)/2)*W/NF*0.29' AS='INT((NF+2)/2)*W/NF*0.29'
+ PD='2*INT((NF+1)/2)*(W/NF+0.29)' PS='2*INT((NF+2)/2)*(W/NF+0.29)' NRD='0.29/W' NRS='0.29/W' SA=0 SB=0 SD=0 MULT=1 M=1
*--------END___XMP20[1]->SKY130_FD_PR__PFET_01V8_LVT
*--------BEGIN_XMP20[0]->SKY130_FD_PR__PFET_01V8_LVT
XMP20[0] MP20D MP1G VDD VDD  SKY130_FD_PR__PFET_01V8_LVT L=1.2 W=0.6 NF=1 AD='INT((NF+1)/2)*W/NF*0.29' AS='INT((NF+2)/2)*W/NF*0.29'
+ PD='2*INT((NF+1)/2)*(W/NF+0.29)' PS='2*INT((NF+2)/2)*(W/NF+0.29)' NRD='0.29/W' NRS='0.29/W' SA=0 SB=0 SD=0 MULT=1 M=1
*--------END___XMP20[0]->SKY130_FD_PR__PFET_01V8_LVT
*--------BEGIN_XMN30->SKY130_FD_PR__NFET_01V8
XMN30 MN1CG EN_B GND GND  SKY130_FD_PR__NFET_01V8 L=0.15 W=0.6 NF=1 AD='INT((NF+1)/2)*W/NF*0.29' AS='INT((NF+2)/2)*W/NF*0.29' PD='2*INT((NF+1)/2)*(W/NF+0.29)'
+ PS='2*INT((NF+2)/2)*(W/NF+0.29)' NRD='0.29/W' NRS='0.29/W' SA=0 SB=0 SD=0 MULT=1 M=1
*--------END___XMN30->SKY130_FD_PR__NFET_01V8
*--------BEGIN_XMN31->SKY130_FD_PR__NFET_01V8
XMN31 MN1G EN_B GND GND  SKY130_FD_PR__NFET_01V8 L=0.15 W=0.6 NF=1 AD='INT((NF+1)/2)*W/NF*0.29' AS='INT((NF+2)/2)*W/NF*0.29' PD='2*INT((NF+1)/2)*(W/NF+0.29)'
+ PS='2*INT((NF+2)/2)*(W/NF+0.29)' NRD='0.29/W' NRS='0.29/W' SA=0 SB=0 SD=0 MULT=1 M=1
*--------END___XMN31->SKY130_FD_PR__NFET_01V8
*--------BEGIN_XMP21P->SKY130_FD_PR__PFET_01V8_LVT
XMP21P MP21PD VC_REPL MP20D VDD  SKY130_FD_PR__PFET_01V8_LVT L=0.35 W=0.6 NF=1 AD='INT((NF+1)/2)*W/NF*0.29' AS='INT((NF+2)/2)*W/NF*0.29'
+ PD='2*INT((NF+1)/2)*(W/NF+0.29)' PS='2*INT((NF+2)/2)*(W/NF+0.29)' NRD='0.29/W' NRS='0.29/W' SA=0 SB=0 SD=0 MULT=1 M=1
*--------END___XMP21P->SKY130_FD_PR__PFET_01V8_LVT
*--------BEGIN_XMP21N->SKY130_FD_PR__PFET_01V8_LVT
XMP21N MP21ND VC2 MP20D VDD  SKY130_FD_PR__PFET_01V8_LVT L=0.35 W=0.6 NF=1 AD='INT((NF+1)/2)*W/NF*0.29' AS='INT((NF+2)/2)*W/NF*0.29'
+ PD='2*INT((NF+1)/2)*(W/NF+0.29)' PS='2*INT((NF+2)/2)*(W/NF+0.29)' NRD='0.29/W' NRS='0.29/W' SA=0 SB=0 SD=0 MULT=1 M=1
*--------END___XMP21N->SKY130_FD_PR__PFET_01V8_LVT
*--------BEGIN_XMN24->SKY130_FD_PR__NFET_01V8
XMN24 NET2 NET3 GND GND  SKY130_FD_PR__NFET_01V8 L=1.2 W=0.6 NF=1 AD='INT((NF+1)/2)*W/NF*0.29' AS='INT((NF+2)/2)*W/NF*0.29' PD='2*INT((NF+1)/2)*(W/NF+0.29)'
+ PS='2*INT((NF+2)/2)*(W/NF+0.29)' NRD='0.29/W' NRS='0.29/W' SA=0 SB=0 SD=0 MULT=1 M=1
*--------END___XMN24->SKY130_FD_PR__NFET_01V8
*--------BEGIN_XMN23->SKY130_FD_PR__NFET_01V8
XMN23 MN1D NET3 GND GND  SKY130_FD_PR__NFET_01V8 L=1.2 W=0.6 NF=1 AD='INT((NF+1)/2)*W/NF*0.29' AS='INT((NF+2)/2)*W/NF*0.29' PD='2*INT((NF+1)/2)*(W/NF+0.29)'
+ PS='2*INT((NF+2)/2)*(W/NF+0.29)' NRD='0.29/W' NRS='0.29/W' SA=0 SB=0 SD=0 MULT=1 M=1
*--------END___XMN23->SKY130_FD_PR__NFET_01V8
*--------BEGIN_XMN24C->SKY130_FD_PR__NFET_01V8
XMN24C NET3 MN1CG NET2 GND  SKY130_FD_PR__NFET_01V8 L=0.3 W=0.6 NF=1 AD='INT((NF+1)/2)*W/NF*0.29' AS='INT((NF+2)/2)*W/NF*0.29' PD='2*INT((NF+1)/2)*(W/NF+0.29)'
+ PS='2*INT((NF+2)/2)*(W/NF+0.29)' NRD='0.29/W' NRS='0.29/W' SA=0 SB=0 SD=0 MULT=1 M=1
*--------END___XMN24C->SKY130_FD_PR__NFET_01V8
*--------BEGIN_XMP2_1->SKY130_FD_PR__PFET_01V8_LVT
XMP2_1 MP2D MP2_1G VDD VDD  SKY130_FD_PR__PFET_01V8_LVT L=1.2 W=0.6 NF=1 AD='INT((NF+1)/2)*W/NF*0.29' AS='INT((NF+2)/2)*W/NF*0.29'
+ PD='2*INT((NF+1)/2)*(W/NF+0.29)' PS='2*INT((NF+2)/2)*(W/NF+0.29)' NRD='0.29/W' NRS='0.29/W' SA=0 SB=0 SD=0 MULT=1 M=1
*--------END___XMP2_1->SKY130_FD_PR__PFET_01V8_LVT
*--------BEGIN_XMP2_1P5->SKY130_FD_PR__PFET_01V8_LVT
XMP2_1P5 MP2D MP2_1P5G VDD VDD  SKY130_FD_PR__PFET_01V8_LVT L=1.2 W=0.9 NF=1 AD='INT((NF+1)/2)*W/NF*0.29' AS='INT((NF+2)/2)*W/NF*0.29'
+ PD='2*INT((NF+1)/2)*(W/NF+0.29)' PS='2*INT((NF+2)/2)*(W/NF+0.29)' NRD='0.29/W' NRS='0.29/W' SA=0 SB=0 SD=0 MULT=1 M=1
*--------END___XMP2_1P5->SKY130_FD_PR__PFET_01V8_LVT
*--------BEGIN_XMP32->SKY130_FD_PR__PFET_01V8_HVT
XMP32 MP2_1P5G B_BB[1] VDD VDD  SKY130_FD_PR__PFET_01V8_HVT L=0.15 W=1.2 NF=1 AD='INT((NF+1)/2)*W/NF*0.29' AS='INT((NF+2)/2)*W/NF*0.29'
+ PD='2*INT((NF+1)/2)*(W/NF+0.29)' PS='2*INT((NF+2)/2)*(W/NF+0.29)' NRD='0.29/W' NRS='0.29/W' SA=0 SB=0 SD=0 MULT=1 M=1
*--------END___XMP32->SKY130_FD_PR__PFET_01V8_HVT
*--------BEGIN_XMP3C->SKY130_FD_PR__PFET_01V8_LVT
XMP3C MN1G IBNP_1U NET4 VDD  SKY130_FD_PR__PFET_01V8_LVT L=0.35 W=1.2 NF=1 AD='INT((NF+1)/2)*W/NF*0.29' AS='INT((NF+2)/2)*W/NF*0.29'
+ PD='2*INT((NF+1)/2)*(W/NF+0.29)' PS='2*INT((NF+2)/2)*(W/NF+0.29)' NRD='0.29/W' NRS='0.29/W' SA=0 SB=0 SD=0 MULT=1 M=1
*--------END___XMP3C->SKY130_FD_PR__PFET_01V8_LVT
*--------BEGIN_XMP3[2]->SKY130_FD_PR__PFET_01V8_LVT
XMP3[2] NET4 MP1G VDD VDD  SKY130_FD_PR__PFET_01V8_LVT L=1.2 W=0.6 NF=1 AD='INT((NF+1)/2)*W/NF*0.29' AS='INT((NF+2)/2)*W/NF*0.29' PD='2*INT((NF+1)/2)*(W/NF+0.29)'
+ PS='2*INT((NF+2)/2)*(W/NF+0.29)' NRD='0.29/W' NRS='0.29/W' SA=0 SB=0 SD=0 MULT=1 M=1
*--------END___XMP3[2]->SKY130_FD_PR__PFET_01V8_LVT
*--------BEGIN_XMP3[1]->SKY130_FD_PR__PFET_01V8_LVT
XMP3[1] NET4 MP1G VDD VDD  SKY130_FD_PR__PFET_01V8_LVT L=1.2 W=0.6 NF=1 AD='INT((NF+1)/2)*W/NF*0.29' AS='INT((NF+2)/2)*W/NF*0.29' PD='2*INT((NF+1)/2)*(W/NF+0.29)'
+ PS='2*INT((NF+2)/2)*(W/NF+0.29)' NRD='0.29/W' NRS='0.29/W' SA=0 SB=0 SD=0 MULT=1 M=1
*--------END___XMP3[1]->SKY130_FD_PR__PFET_01V8_LVT
*--------BEGIN_XMP3[0]->SKY130_FD_PR__PFET_01V8_LVT
XMP3[0] NET4 MP1G VDD VDD  SKY130_FD_PR__PFET_01V8_LVT L=1.2 W=0.6 NF=1 AD='INT((NF+1)/2)*W/NF*0.29' AS='INT((NF+2)/2)*W/NF*0.29' PD='2*INT((NF+1)/2)*(W/NF+0.29)'
+ PS='2*INT((NF+2)/2)*(W/NF+0.29)' NRD='0.29/W' NRS='0.29/W' SA=0 SB=0 SD=0 MULT=1 M=1
*--------END___XMP3[0]->SKY130_FD_PR__PFET_01V8_LVT
*--------BEGIN_X1->EFX_PLL96_DBUF
*.IPIN A
*.IOPIN VDD
*.IOPIN GND
*.OPIN Y
*.OPIN Y_B
*--------BEGIN_X1_XMP1->SKY130_FD_PR__PFET_01V8_HVT
XMP1_X1 EN_B EN VDD VDD  SKY130_FD_PR__PFET_01V8_HVT L=0.15 W=1.2 NF=1 AD='INT((NF+1)/2)*W/NF*0.29' AS='INT((NF+2)/2)*W/NF*0.29' PD='2*INT((NF+1)/2)*(W/NF+0.29)'
+ PS='2*INT((NF+2)/2)*(W/NF+0.29)' NRD='0.29/W' NRS='0.29/W' SA=0 SB=0 SD=0 MULT=1 M=1
*--------END___X1_XMP1->SKY130_FD_PR__PFET_01V8_HVT
*--------BEGIN_X1_XMP3->SKY130_FD_PR__PFET_01V8_HVT
XMP3_X1 EN_BB EN_B VDD VDD  SKY130_FD_PR__PFET_01V8_HVT L=0.15 W=1.2 NF=1 AD='INT((NF+1)/2)*W/NF*0.29' AS='INT((NF+2)/2)*W/NF*0.29'
+ PD='2*INT((NF+1)/2)*(W/NF+0.29)' PS='2*INT((NF+2)/2)*(W/NF+0.29)' NRD='0.29/W' NRS='0.29/W' SA=0 SB=0 SD=0 MULT=1 M=1
*--------END___X1_XMP3->SKY130_FD_PR__PFET_01V8_HVT
*--------BEGIN_X1_XMN4->SKY130_FD_PR__NFET_01V8
XMN4_X1 EN_BB EN_B GND GND  SKY130_FD_PR__NFET_01V8 L=0.15 W=0.74 NF=1 AD='INT((NF+1)/2)*W/NF*0.29' AS='INT((NF+2)/2)*W/NF*0.29' PD='2*INT((NF+1)/2)*(W/NF+0.29)'
+ PS='2*INT((NF+2)/2)*(W/NF+0.29)' NRD='0.29/W' NRS='0.29/W' SA=0 SB=0 SD=0 MULT=1 M=1
*--------END___X1_XMN4->SKY130_FD_PR__NFET_01V8
*--------BEGIN_X1_XMN2->SKY130_FD_PR__NFET_01V8
XMN2_X1 EN_B EN GND GND  SKY130_FD_PR__NFET_01V8 L=0.15 W=0.74 NF=1 AD='INT((NF+1)/2)*W/NF*0.29' AS='INT((NF+2)/2)*W/NF*0.29' PD='2*INT((NF+1)/2)*(W/NF+0.29)'
+ PS='2*INT((NF+2)/2)*(W/NF+0.29)' NRD='0.29/W' NRS='0.29/W' SA=0 SB=0 SD=0 MULT=1 M=1
*--------END___X1_XMN2->SKY130_FD_PR__NFET_01V8
**** BEGIN USER ARCHITECTURE CODE

* COPYRIGHT (C) ERIC FOGLEMAN 2025
* SPDX-LICENSE-IDENTIFIER: APACHE-2.0

**** END USER ARCHITECTURE CODE
*--------END___X1->EFX_PLL96_DBUF
*--------BEGIN_X3[2]->EFX_PLL96_DBUF
*.IPIN A
*.IOPIN VDD
*.IOPIN GND
*.OPIN Y
*.OPIN Y_B
*--------BEGIN_X3[2]_XMP1->SKY130_FD_PR__PFET_01V8_HVT
XMP1_X3[2] B_B[2] B[2] VDD VDD  SKY130_FD_PR__PFET_01V8_HVT L=0.15 W=1.2 NF=1 AD='INT((NF+1)/2)*W/NF*0.29' AS='INT((NF+2)/2)*W/NF*0.29'
+ PD='2*INT((NF+1)/2)*(W/NF+0.29)' PS='2*INT((NF+2)/2)*(W/NF+0.29)' NRD='0.29/W' NRS='0.29/W' SA=0 SB=0 SD=0 MULT=1 M=1
*--------END___X3[2]_XMP1->SKY130_FD_PR__PFET_01V8_HVT
*--------BEGIN_X3[2]_XMP3->SKY130_FD_PR__PFET_01V8_HVT
XMP3_X3[2] B_BB[2] B_B[2] VDD VDD  SKY130_FD_PR__PFET_01V8_HVT L=0.15 W=1.2 NF=1 AD='INT((NF+1)/2)*W/NF*0.29' AS='INT((NF+2)/2)*W/NF*0.29'
+ PD='2*INT((NF+1)/2)*(W/NF+0.29)' PS='2*INT((NF+2)/2)*(W/NF+0.29)' NRD='0.29/W' NRS='0.29/W' SA=0 SB=0 SD=0 MULT=1 M=1
*--------END___X3[2]_XMP3->SKY130_FD_PR__PFET_01V8_HVT
*--------BEGIN_X3[2]_XMN4->SKY130_FD_PR__NFET_01V8
XMN4_X3[2] B_BB[2] B_B[2] GND GND  SKY130_FD_PR__NFET_01V8 L=0.15 W=0.74 NF=1 AD='INT((NF+1)/2)*W/NF*0.29' AS='INT((NF+2)/2)*W/NF*0.29'
+ PD='2*INT((NF+1)/2)*(W/NF+0.29)' PS='2*INT((NF+2)/2)*(W/NF+0.29)' NRD='0.29/W' NRS='0.29/W' SA=0 SB=0 SD=0 MULT=1 M=1
*--------END___X3[2]_XMN4->SKY130_FD_PR__NFET_01V8
*--------BEGIN_X3[2]_XMN2->SKY130_FD_PR__NFET_01V8
XMN2_X3[2] B_B[2] B[2] GND GND  SKY130_FD_PR__NFET_01V8 L=0.15 W=0.74 NF=1 AD='INT((NF+1)/2)*W/NF*0.29' AS='INT((NF+2)/2)*W/NF*0.29'
+ PD='2*INT((NF+1)/2)*(W/NF+0.29)' PS='2*INT((NF+2)/2)*(W/NF+0.29)' NRD='0.29/W' NRS='0.29/W' SA=0 SB=0 SD=0 MULT=1 M=1
*--------END___X3[2]_XMN2->SKY130_FD_PR__NFET_01V8
**** BEGIN USER ARCHITECTURE CODE

* COPYRIGHT (C) ERIC FOGLEMAN 2025
* SPDX-LICENSE-IDENTIFIER: APACHE-2.0

**** END USER ARCHITECTURE CODE
*--------END___X3[2]->EFX_PLL96_DBUF
*--------BEGIN_X3[1]->EFX_PLL96_DBUF
*.IPIN A
*.IOPIN VDD
*.IOPIN GND
*.OPIN Y
*.OPIN Y_B
*--------BEGIN_X3[1]_XMP1->SKY130_FD_PR__PFET_01V8_HVT
XMP1_X3[1] B_B[1] B[1] VDD VDD  SKY130_FD_PR__PFET_01V8_HVT L=0.15 W=1.2 NF=1 AD='INT((NF+1)/2)*W/NF*0.29' AS='INT((NF+2)/2)*W/NF*0.29'
+ PD='2*INT((NF+1)/2)*(W/NF+0.29)' PS='2*INT((NF+2)/2)*(W/NF+0.29)' NRD='0.29/W' NRS='0.29/W' SA=0 SB=0 SD=0 MULT=1 M=1
*--------END___X3[1]_XMP1->SKY130_FD_PR__PFET_01V8_HVT
*--------BEGIN_X3[1]_XMP3->SKY130_FD_PR__PFET_01V8_HVT
XMP3_X3[1] B_BB[1] B_B[1] VDD VDD  SKY130_FD_PR__PFET_01V8_HVT L=0.15 W=1.2 NF=1 AD='INT((NF+1)/2)*W/NF*0.29' AS='INT((NF+2)/2)*W/NF*0.29'
+ PD='2*INT((NF+1)/2)*(W/NF+0.29)' PS='2*INT((NF+2)/2)*(W/NF+0.29)' NRD='0.29/W' NRS='0.29/W' SA=0 SB=0 SD=0 MULT=1 M=1
*--------END___X3[1]_XMP3->SKY130_FD_PR__PFET_01V8_HVT
*--------BEGIN_X3[1]_XMN4->SKY130_FD_PR__NFET_01V8
XMN4_X3[1] B_BB[1] B_B[1] GND GND  SKY130_FD_PR__NFET_01V8 L=0.15 W=0.74 NF=1 AD='INT((NF+1)/2)*W/NF*0.29' AS='INT((NF+2)/2)*W/NF*0.29'
+ PD='2*INT((NF+1)/2)*(W/NF+0.29)' PS='2*INT((NF+2)/2)*(W/NF+0.29)' NRD='0.29/W' NRS='0.29/W' SA=0 SB=0 SD=0 MULT=1 M=1
*--------END___X3[1]_XMN4->SKY130_FD_PR__NFET_01V8
*--------BEGIN_X3[1]_XMN2->SKY130_FD_PR__NFET_01V8
XMN2_X3[1] B_B[1] B[1] GND GND  SKY130_FD_PR__NFET_01V8 L=0.15 W=0.74 NF=1 AD='INT((NF+1)/2)*W/NF*0.29' AS='INT((NF+2)/2)*W/NF*0.29'
+ PD='2*INT((NF+1)/2)*(W/NF+0.29)' PS='2*INT((NF+2)/2)*(W/NF+0.29)' NRD='0.29/W' NRS='0.29/W' SA=0 SB=0 SD=0 MULT=1 M=1
*--------END___X3[1]_XMN2->SKY130_FD_PR__NFET_01V8
**** BEGIN USER ARCHITECTURE CODE

* COPYRIGHT (C) ERIC FOGLEMAN 2025
* SPDX-LICENSE-IDENTIFIER: APACHE-2.0

**** END USER ARCHITECTURE CODE
*--------END___X3[1]->EFX_PLL96_DBUF
*--------BEGIN_X3[0]->EFX_PLL96_DBUF
*.IPIN A
*.IOPIN VDD
*.IOPIN GND
*.OPIN Y
*.OPIN Y_B
*--------BEGIN_X3[0]_XMP1->SKY130_FD_PR__PFET_01V8_HVT
XMP1_X3[0] B_B[0] B[0] VDD VDD  SKY130_FD_PR__PFET_01V8_HVT L=0.15 W=1.2 NF=1 AD='INT((NF+1)/2)*W/NF*0.29' AS='INT((NF+2)/2)*W/NF*0.29'
+ PD='2*INT((NF+1)/2)*(W/NF+0.29)' PS='2*INT((NF+2)/2)*(W/NF+0.29)' NRD='0.29/W' NRS='0.29/W' SA=0 SB=0 SD=0 MULT=1 M=1
*--------END___X3[0]_XMP1->SKY130_FD_PR__PFET_01V8_HVT
*--------BEGIN_X3[0]_XMP3->SKY130_FD_PR__PFET_01V8_HVT
XMP3_X3[0] B_BB[0] B_B[0] VDD VDD  SKY130_FD_PR__PFET_01V8_HVT L=0.15 W=1.2 NF=1 AD='INT((NF+1)/2)*W/NF*0.29' AS='INT((NF+2)/2)*W/NF*0.29'
+ PD='2*INT((NF+1)/2)*(W/NF+0.29)' PS='2*INT((NF+2)/2)*(W/NF+0.29)' NRD='0.29/W' NRS='0.29/W' SA=0 SB=0 SD=0 MULT=1 M=1
*--------END___X3[0]_XMP3->SKY130_FD_PR__PFET_01V8_HVT
*--------BEGIN_X3[0]_XMN4->SKY130_FD_PR__NFET_01V8
XMN4_X3[0] B_BB[0] B_B[0] GND GND  SKY130_FD_PR__NFET_01V8 L=0.15 W=0.74 NF=1 AD='INT((NF+1)/2)*W/NF*0.29' AS='INT((NF+2)/2)*W/NF*0.29'
+ PD='2*INT((NF+1)/2)*(W/NF+0.29)' PS='2*INT((NF+2)/2)*(W/NF+0.29)' NRD='0.29/W' NRS='0.29/W' SA=0 SB=0 SD=0 MULT=1 M=1
*--------END___X3[0]_XMN4->SKY130_FD_PR__NFET_01V8
*--------BEGIN_X3[0]_XMN2->SKY130_FD_PR__NFET_01V8
XMN2_X3[0] B_B[0] B[0] GND GND  SKY130_FD_PR__NFET_01V8 L=0.15 W=0.74 NF=1 AD='INT((NF+1)/2)*W/NF*0.29' AS='INT((NF+2)/2)*W/NF*0.29'
+ PD='2*INT((NF+1)/2)*(W/NF+0.29)' PS='2*INT((NF+2)/2)*(W/NF+0.29)' NRD='0.29/W' NRS='0.29/W' SA=0 SB=0 SD=0 MULT=1 M=1
*--------END___X3[0]_XMN2->SKY130_FD_PR__NFET_01V8
**** BEGIN USER ARCHITECTURE CODE

* COPYRIGHT (C) ERIC FOGLEMAN 2025
* SPDX-LICENSE-IDENTIFIER: APACHE-2.0

**** END USER ARCHITECTURE CODE
*--------END___X3[0]->EFX_PLL96_DBUF
*--------BEGIN_XMP42->SKY130_FD_PR__PFET_01V8_HVT
XMP42 MP1G B_B[1] MP2_1P5G VDD  SKY130_FD_PR__PFET_01V8_HVT L=0.15 W=1.2 NF=1 AD='INT((NF+1)/2)*W/NF*0.29' AS='INT((NF+2)/2)*W/NF*0.29'
+ PD='2*INT((NF+1)/2)*(W/NF+0.29)' PS='2*INT((NF+2)/2)*(W/NF+0.29)' NRD='0.29/W' NRS='0.29/W' SA=0 SB=0 SD=0 MULT=1 M=1
*--------END___XMP42->SKY130_FD_PR__PFET_01V8_HVT
*--------BEGIN_XMP33->SKY130_FD_PR__PFET_01V8_HVT
XMP33 MP2_1G B_BB[0] VDD VDD  SKY130_FD_PR__PFET_01V8_HVT L=0.15 W=1.2 NF=1 AD='INT((NF+1)/2)*W/NF*0.29' AS='INT((NF+2)/2)*W/NF*0.29'
+ PD='2*INT((NF+1)/2)*(W/NF+0.29)' PS='2*INT((NF+2)/2)*(W/NF+0.29)' NRD='0.29/W' NRS='0.29/W' SA=0 SB=0 SD=0 MULT=1 M=1
*--------END___XMP33->SKY130_FD_PR__PFET_01V8_HVT
*--------BEGIN_XMP43->SKY130_FD_PR__PFET_01V8_HVT
XMP43 MP1G B_B[0] MP2_1G VDD  SKY130_FD_PR__PFET_01V8_HVT L=0.15 W=1.2 NF=1 AD='INT((NF+1)/2)*W/NF*0.29' AS='INT((NF+2)/2)*W/NF*0.29'
+ PD='2*INT((NF+1)/2)*(W/NF+0.29)' PS='2*INT((NF+2)/2)*(W/NF+0.29)' NRD='0.29/W' NRS='0.29/W' SA=0 SB=0 SD=0 MULT=1 M=1
*--------END___XMP43->SKY130_FD_PR__PFET_01V8_HVT
*--------BEGIN_XMP30->SKY130_FD_PR__PFET_01V8_HVT
XMP30 IBNP_1U EN_BB VDD VDD  SKY130_FD_PR__PFET_01V8_HVT L=0.15 W=0.6 NF=1 AD='INT((NF+1)/2)*W/NF*0.29' AS='INT((NF+2)/2)*W/NF*0.29'
+ PD='2*INT((NF+1)/2)*(W/NF+0.29)' PS='2*INT((NF+2)/2)*(W/NF+0.29)' NRD='0.29/W' NRS='0.29/W' SA=0 SB=0 SD=0 MULT=1 M=1
*--------END___XMP30->SKY130_FD_PR__PFET_01V8_HVT
*--------BEGIN_XMP31->SKY130_FD_PR__PFET_01V8_HVT
XMP31 MP1G EN_BB VDD VDD  SKY130_FD_PR__PFET_01V8_HVT L=0.15 W=0.6 NF=1 AD='INT((NF+1)/2)*W/NF*0.29' AS='INT((NF+2)/2)*W/NF*0.29' PD='2*INT((NF+1)/2)*(W/NF+0.29)'
+ PS='2*INT((NF+2)/2)*(W/NF+0.29)' NRD='0.29/W' NRS='0.29/W' SA=0 SB=0 SD=0 MULT=1 M=1
*--------END___XMP31->SKY130_FD_PR__PFET_01V8_HVT
*--------BEGIN_XR5[1]->SKY130_FD_PR__RES_XHIGH_PO_0P69
XR5[1] VDD VDD VDD  SKY130_FD_PR__RES_XHIGH_PO_0P69 L=8.97 MULT=1 M=1
*--------END___XR5[1]->SKY130_FD_PR__RES_XHIGH_PO_0P69
*--------BEGIN_XR5[0]->SKY130_FD_PR__RES_XHIGH_PO_0P69
XR5[0] VDD VDD VDD  SKY130_FD_PR__RES_XHIGH_PO_0P69 L=8.97 MULT=1 M=1
*--------END___XR5[0]->SKY130_FD_PR__RES_XHIGH_PO_0P69
*--------BEGIN_XMP34->SKY130_FD_PR__PFET_01V8_HVT
XMP34 MP2_2G B_BB[2] VDD VDD  SKY130_FD_PR__PFET_01V8_HVT L=0.15 W=1.2 NF=1 AD='INT((NF+1)/2)*W/NF*0.29' AS='INT((NF+2)/2)*W/NF*0.29'
+ PD='2*INT((NF+1)/2)*(W/NF+0.29)' PS='2*INT((NF+2)/2)*(W/NF+0.29)' NRD='0.29/W' NRS='0.29/W' SA=0 SB=0 SD=0 MULT=1 M=1
*--------END___XMP34->SKY130_FD_PR__PFET_01V8_HVT
*--------BEGIN_XMP44->SKY130_FD_PR__PFET_01V8_HVT
XMP44 MP1G B_B[2] MP2_2G VDD  SKY130_FD_PR__PFET_01V8_HVT L=0.15 W=1.2 NF=1 AD='INT((NF+1)/2)*W/NF*0.29' AS='INT((NF+2)/2)*W/NF*0.29'
+ PD='2*INT((NF+1)/2)*(W/NF+0.29)' PS='2*INT((NF+2)/2)*(W/NF+0.29)' NRD='0.29/W' NRS='0.29/W' SA=0 SB=0 SD=0 MULT=1 M=1
*--------END___XMP44->SKY130_FD_PR__PFET_01V8_HVT
*--------BEGIN_XR1->SKY130_FD_PR__RES_XHIGH_PO_0P69
XR1 NET6 NET7 VDD  SKY130_FD_PR__RES_XHIGH_PO_0P69 L=8.97 MULT=1 M=1
*--------END___XR1->SKY130_FD_PR__RES_XHIGH_PO_0P69
*--------BEGIN_XR2->SKY130_FD_PR__RES_XHIGH_PO_0P69
XR2 IBNP_1U NET6 VDD  SKY130_FD_PR__RES_XHIGH_PO_0P69 L=8.97 MULT=1 M=1
*--------END___XR2->SKY130_FD_PR__RES_XHIGH_PO_0P69
*--------BEGIN_XR3->SKY130_FD_PR__RES_XHIGH_PO_0P69
XR3 NET7 NET5 VDD  SKY130_FD_PR__RES_XHIGH_PO_0P69 L=8.97 MULT=1 M=1
*--------END___XR3->SKY130_FD_PR__RES_XHIGH_PO_0P69
*--------BEGIN_XR4->SKY130_FD_PR__RES_XHIGH_PO_0P69
XR4 NET5 MP1G VDD  SKY130_FD_PR__RES_XHIGH_PO_0P69 L=8.97 MULT=1 M=1
*--------END___XR4->SKY130_FD_PR__RES_XHIGH_PO_0P69
*--------BEGIN_XMP4C->SKY130_FD_PR__PFET_01V8_LVT
XMP4C MN1CG IBNP_1U NET8 VDD  SKY130_FD_PR__PFET_01V8_LVT L=0.35 W=1.2 NF=1 AD='INT((NF+1)/2)*W/NF*0.29' AS='INT((NF+2)/2)*W/NF*0.29'
+ PD='2*INT((NF+1)/2)*(W/NF+0.29)' PS='2*INT((NF+2)/2)*(W/NF+0.29)' NRD='0.29/W' NRS='0.29/W' SA=0 SB=0 SD=0 MULT=1 M=1
*--------END___XMP4C->SKY130_FD_PR__PFET_01V8_LVT
*--------BEGIN_XMP4[2]->SKY130_FD_PR__PFET_01V8_LVT
XMP4[2] NET8 MP1G VDD VDD  SKY130_FD_PR__PFET_01V8_LVT L=1.2 W=0.6 NF=1 AD='INT((NF+1)/2)*W/NF*0.29' AS='INT((NF+2)/2)*W/NF*0.29' PD='2*INT((NF+1)/2)*(W/NF+0.29)'
+ PS='2*INT((NF+2)/2)*(W/NF+0.29)' NRD='0.29/W' NRS='0.29/W' SA=0 SB=0 SD=0 MULT=1 M=1
*--------END___XMP4[2]->SKY130_FD_PR__PFET_01V8_LVT
*--------BEGIN_XMP4[1]->SKY130_FD_PR__PFET_01V8_LVT
XMP4[1] NET8 MP1G VDD VDD  SKY130_FD_PR__PFET_01V8_LVT L=1.2 W=0.6 NF=1 AD='INT((NF+1)/2)*W/NF*0.29' AS='INT((NF+2)/2)*W/NF*0.29' PD='2*INT((NF+1)/2)*(W/NF+0.29)'
+ PS='2*INT((NF+2)/2)*(W/NF+0.29)' NRD='0.29/W' NRS='0.29/W' SA=0 SB=0 SD=0 MULT=1 M=1
*--------END___XMP4[1]->SKY130_FD_PR__PFET_01V8_LVT
*--------BEGIN_XMP4[0]->SKY130_FD_PR__PFET_01V8_LVT
XMP4[0] NET8 MP1G VDD VDD  SKY130_FD_PR__PFET_01V8_LVT L=1.2 W=0.6 NF=1 AD='INT((NF+1)/2)*W/NF*0.29' AS='INT((NF+2)/2)*W/NF*0.29' PD='2*INT((NF+1)/2)*(W/NF+0.29)'
+ PS='2*INT((NF+2)/2)*(W/NF+0.29)' NRD='0.29/W' NRS='0.29/W' SA=0 SB=0 SD=0 MULT=1 M=1
*--------END___XMP4[0]->SKY130_FD_PR__PFET_01V8_LVT
*--------BEGIN_XMN4[0]->SKY130_FD_PR__NFET_01V8
XMN4[0] NET11 MN1CG GND GND  SKY130_FD_PR__NFET_01V8 L=1.2 W=0.6 NF=1 AD='INT((NF+1)/2)*W/NF*0.29' AS='INT((NF+2)/2)*W/NF*0.29' PD='2*INT((NF+1)/2)*(W/NF+0.29)'
+ PS='2*INT((NF+2)/2)*(W/NF+0.29)' NRD='0.29/W' NRS='0.29/W' SA=0 SB=0 SD=0 MULT=1 M=1
*--------END___XMN4[0]->SKY130_FD_PR__NFET_01V8
*--------BEGIN_XMN4[1]->SKY130_FD_PR__NFET_01V8
XMN4[1] NET10 MN1CG NET11 GND  SKY130_FD_PR__NFET_01V8 L=1.2 W=0.6 NF=1 AD='INT((NF+1)/2)*W/NF*0.29' AS='INT((NF+2)/2)*W/NF*0.29' PD='2*INT((NF+1)/2)*(W/NF+0.29)'
+ PS='2*INT((NF+2)/2)*(W/NF+0.29)' NRD='0.29/W' NRS='0.29/W' SA=0 SB=0 SD=0 MULT=1 M=1
*--------END___XMN4[1]->SKY130_FD_PR__NFET_01V8
*--------BEGIN_XMN4[2]->SKY130_FD_PR__NFET_01V8
XMN4[2] NET9 MN1CG NET10 GND  SKY130_FD_PR__NFET_01V8 L=1.2 W=0.6 NF=1 AD='INT((NF+1)/2)*W/NF*0.29' AS='INT((NF+2)/2)*W/NF*0.29' PD='2*INT((NF+1)/2)*(W/NF+0.29)'
+ PS='2*INT((NF+2)/2)*(W/NF+0.29)' NRD='0.29/W' NRS='0.29/W' SA=0 SB=0 SD=0 MULT=1 M=1
*--------END___XMN4[2]->SKY130_FD_PR__NFET_01V8
*--------BEGIN_XMN4[3]->SKY130_FD_PR__NFET_01V8
XMN4[3] NET12 MN1CG NET9 GND  SKY130_FD_PR__NFET_01V8 L=1.2 W=0.6 NF=1 AD='INT((NF+1)/2)*W/NF*0.29' AS='INT((NF+2)/2)*W/NF*0.29' PD='2*INT((NF+1)/2)*(W/NF+0.29)'
+ PS='2*INT((NF+2)/2)*(W/NF+0.29)' NRD='0.29/W' NRS='0.29/W' SA=0 SB=0 SD=0 MULT=1 M=1
*--------END___XMN4[3]->SKY130_FD_PR__NFET_01V8
*--------BEGIN_XMN4[4]->SKY130_FD_PR__NFET_01V8
XMN4[4] NET14 MN1CG NET12 GND  SKY130_FD_PR__NFET_01V8 L=1.2 W=0.6 NF=1 AD='INT((NF+1)/2)*W/NF*0.29' AS='INT((NF+2)/2)*W/NF*0.29' PD='2*INT((NF+1)/2)*(W/NF+0.29)'
+ PS='2*INT((NF+2)/2)*(W/NF+0.29)' NRD='0.29/W' NRS='0.29/W' SA=0 SB=0 SD=0 MULT=1 M=1
*--------END___XMN4[4]->SKY130_FD_PR__NFET_01V8
*--------BEGIN_XMP26[2]->SKY130_FD_PR__PFET_01V8_LVT
XMP26[2] MP20D MP1G VDD VDD  SKY130_FD_PR__PFET_01V8_LVT L=1.2 W=0.6 NF=1 AD='INT((NF+1)/2)*W/NF*0.29' AS='INT((NF+2)/2)*W/NF*0.29'
+ PD='2*INT((NF+1)/2)*(W/NF+0.29)' PS='2*INT((NF+2)/2)*(W/NF+0.29)' NRD='0.29/W' NRS='0.29/W' SA=0 SB=0 SD=0 MULT=1 M=1
*--------END___XMP26[2]->SKY130_FD_PR__PFET_01V8_LVT
*--------BEGIN_XMP26[1]->SKY130_FD_PR__PFET_01V8_LVT
XMP26[1] MP20D MP1G VDD VDD  SKY130_FD_PR__PFET_01V8_LVT L=1.2 W=0.6 NF=1 AD='INT((NF+1)/2)*W/NF*0.29' AS='INT((NF+2)/2)*W/NF*0.29'
+ PD='2*INT((NF+1)/2)*(W/NF+0.29)' PS='2*INT((NF+2)/2)*(W/NF+0.29)' NRD='0.29/W' NRS='0.29/W' SA=0 SB=0 SD=0 MULT=1 M=1
*--------END___XMP26[1]->SKY130_FD_PR__PFET_01V8_LVT
*--------BEGIN_XMP26[0]->SKY130_FD_PR__PFET_01V8_LVT
XMP26[0] MP20D MP1G VDD VDD  SKY130_FD_PR__PFET_01V8_LVT L=1.2 W=0.6 NF=1 AD='INT((NF+1)/2)*W/NF*0.29' AS='INT((NF+2)/2)*W/NF*0.29'
+ PD='2*INT((NF+1)/2)*(W/NF+0.29)' PS='2*INT((NF+2)/2)*(W/NF+0.29)' NRD='0.29/W' NRS='0.29/W' SA=0 SB=0 SD=0 MULT=1 M=1
*--------END___XMP26[0]->SKY130_FD_PR__PFET_01V8_LVT
*--------BEGIN_XMN25->SKY130_FD_PR__NFET_01V8
XMN25 NET13 NET3 GND GND  SKY130_FD_PR__NFET_01V8 L=1.2 W=0.6 NF=1 AD='INT((NF+1)/2)*W/NF*0.29' AS='INT((NF+2)/2)*W/NF*0.29' PD='2*INT((NF+1)/2)*(W/NF+0.29)'
+ PS='2*INT((NF+2)/2)*(W/NF+0.29)' NRD='0.29/W' NRS='0.29/W' SA=0 SB=0 SD=0 MULT=1 M=1
*--------END___XMN25->SKY130_FD_PR__NFET_01V8
*--------BEGIN_XMN25C->SKY130_FD_PR__NFET_01V8
XMN25C MP21CG MN1CG NET13 GND  SKY130_FD_PR__NFET_01V8 L=0.3 W=0.6 NF=1 AD='INT((NF+1)/2)*W/NF*0.29' AS='INT((NF+2)/2)*W/NF*0.29' PD='2*INT((NF+1)/2)*(W/NF+0.29)'
+ PS='2*INT((NF+2)/2)*(W/NF+0.29)' NRD='0.29/W' NRS='0.29/W' SA=0 SB=0 SD=0 MULT=1 M=1
*--------END___XMN25C->SKY130_FD_PR__NFET_01V8
*--------BEGIN_XMN4[5]->SKY130_FD_PR__NFET_01V8
XMN4[5] MN1CG MN1CG NET14 GND  SKY130_FD_PR__NFET_01V8 L=1.2 W=0.6 NF=1 AD='INT((NF+1)/2)*W/NF*0.29' AS='INT((NF+2)/2)*W/NF*0.29' PD='2*INT((NF+1)/2)*(W/NF+0.29)'
+ PS='2*INT((NF+2)/2)*(W/NF+0.29)' NRD='0.29/W' NRS='0.29/W' SA=0 SB=0 SD=0 MULT=1 M=1
*--------END___XMN4[5]->SKY130_FD_PR__NFET_01V8
*--------BEGIN_XMNCAP1[9]->SKY130_FD_PR__NFET_01V8
XMNCAP1[9] GND VC_REPL GND GND  SKY130_FD_PR__NFET_01V8 L=2 W=8 NF=2 AD='INT((NF+1)/2)*W/NF*0.29' AS='INT((NF+2)/2)*W/NF*0.29' PD='2*INT((NF+1)/2)*(W/NF+0.29)'
+ PS='2*INT((NF+2)/2)*(W/NF+0.29)' NRD='0.29/W' NRS='0.29/W' SA=0 SB=0 SD=0 MULT=1 M=1
*--------END___XMNCAP1[9]->SKY130_FD_PR__NFET_01V8
*--------BEGIN_XMNCAP1[8]->SKY130_FD_PR__NFET_01V8
XMNCAP1[8] GND VC_REPL GND GND  SKY130_FD_PR__NFET_01V8 L=2 W=8 NF=2 AD='INT((NF+1)/2)*W/NF*0.29' AS='INT((NF+2)/2)*W/NF*0.29' PD='2*INT((NF+1)/2)*(W/NF+0.29)'
+ PS='2*INT((NF+2)/2)*(W/NF+0.29)' NRD='0.29/W' NRS='0.29/W' SA=0 SB=0 SD=0 MULT=1 M=1
*--------END___XMNCAP1[8]->SKY130_FD_PR__NFET_01V8
*--------BEGIN_XMNCAP1[7]->SKY130_FD_PR__NFET_01V8
XMNCAP1[7] GND VC_REPL GND GND  SKY130_FD_PR__NFET_01V8 L=2 W=8 NF=2 AD='INT((NF+1)/2)*W/NF*0.29' AS='INT((NF+2)/2)*W/NF*0.29' PD='2*INT((NF+1)/2)*(W/NF+0.29)'
+ PS='2*INT((NF+2)/2)*(W/NF+0.29)' NRD='0.29/W' NRS='0.29/W' SA=0 SB=0 SD=0 MULT=1 M=1
*--------END___XMNCAP1[7]->SKY130_FD_PR__NFET_01V8
*--------BEGIN_XMNCAP1[6]->SKY130_FD_PR__NFET_01V8
XMNCAP1[6] GND VC_REPL GND GND  SKY130_FD_PR__NFET_01V8 L=2 W=8 NF=2 AD='INT((NF+1)/2)*W/NF*0.29' AS='INT((NF+2)/2)*W/NF*0.29' PD='2*INT((NF+1)/2)*(W/NF+0.29)'
+ PS='2*INT((NF+2)/2)*(W/NF+0.29)' NRD='0.29/W' NRS='0.29/W' SA=0 SB=0 SD=0 MULT=1 M=1
*--------END___XMNCAP1[6]->SKY130_FD_PR__NFET_01V8
*--------BEGIN_XMNCAP1[5]->SKY130_FD_PR__NFET_01V8
XMNCAP1[5] GND VC_REPL GND GND  SKY130_FD_PR__NFET_01V8 L=2 W=8 NF=2 AD='INT((NF+1)/2)*W/NF*0.29' AS='INT((NF+2)/2)*W/NF*0.29' PD='2*INT((NF+1)/2)*(W/NF+0.29)'
+ PS='2*INT((NF+2)/2)*(W/NF+0.29)' NRD='0.29/W' NRS='0.29/W' SA=0 SB=0 SD=0 MULT=1 M=1
*--------END___XMNCAP1[5]->SKY130_FD_PR__NFET_01V8
*--------BEGIN_XMNCAP1[4]->SKY130_FD_PR__NFET_01V8
XMNCAP1[4] GND VC_REPL GND GND  SKY130_FD_PR__NFET_01V8 L=2 W=8 NF=2 AD='INT((NF+1)/2)*W/NF*0.29' AS='INT((NF+2)/2)*W/NF*0.29' PD='2*INT((NF+1)/2)*(W/NF+0.29)'
+ PS='2*INT((NF+2)/2)*(W/NF+0.29)' NRD='0.29/W' NRS='0.29/W' SA=0 SB=0 SD=0 MULT=1 M=1
*--------END___XMNCAP1[4]->SKY130_FD_PR__NFET_01V8
*--------BEGIN_XMNCAP1[3]->SKY130_FD_PR__NFET_01V8
XMNCAP1[3] GND VC_REPL GND GND  SKY130_FD_PR__NFET_01V8 L=2 W=8 NF=2 AD='INT((NF+1)/2)*W/NF*0.29' AS='INT((NF+2)/2)*W/NF*0.29' PD='2*INT((NF+1)/2)*(W/NF+0.29)'
+ PS='2*INT((NF+2)/2)*(W/NF+0.29)' NRD='0.29/W' NRS='0.29/W' SA=0 SB=0 SD=0 MULT=1 M=1
*--------END___XMNCAP1[3]->SKY130_FD_PR__NFET_01V8
*--------BEGIN_XMNCAP1[2]->SKY130_FD_PR__NFET_01V8
XMNCAP1[2] GND VC_REPL GND GND  SKY130_FD_PR__NFET_01V8 L=2 W=8 NF=2 AD='INT((NF+1)/2)*W/NF*0.29' AS='INT((NF+2)/2)*W/NF*0.29' PD='2*INT((NF+1)/2)*(W/NF+0.29)'
+ PS='2*INT((NF+2)/2)*(W/NF+0.29)' NRD='0.29/W' NRS='0.29/W' SA=0 SB=0 SD=0 MULT=1 M=1
*--------END___XMNCAP1[2]->SKY130_FD_PR__NFET_01V8
*--------BEGIN_XMNCAP1[1]->SKY130_FD_PR__NFET_01V8
XMNCAP1[1] GND VC_REPL GND GND  SKY130_FD_PR__NFET_01V8 L=2 W=8 NF=2 AD='INT((NF+1)/2)*W/NF*0.29' AS='INT((NF+2)/2)*W/NF*0.29' PD='2*INT((NF+1)/2)*(W/NF+0.29)'
+ PS='2*INT((NF+2)/2)*(W/NF+0.29)' NRD='0.29/W' NRS='0.29/W' SA=0 SB=0 SD=0 MULT=1 M=1
*--------END___XMNCAP1[1]->SKY130_FD_PR__NFET_01V8
*--------BEGIN_XMNCAP1[0]->SKY130_FD_PR__NFET_01V8
XMNCAP1[0] GND VC_REPL GND GND  SKY130_FD_PR__NFET_01V8 L=2 W=8 NF=2 AD='INT((NF+1)/2)*W/NF*0.29' AS='INT((NF+2)/2)*W/NF*0.29' PD='2*INT((NF+1)/2)*(W/NF+0.29)'
+ PS='2*INT((NF+2)/2)*(W/NF+0.29)' NRD='0.29/W' NRS='0.29/W' SA=0 SB=0 SD=0 MULT=1 M=1
*--------END___XMNCAP1[0]->SKY130_FD_PR__NFET_01V8
*--------BEGIN_XMNCAP2->SKY130_FD_PR__NFET_01V8
XMNCAP2 GND MN1CG GND GND  SKY130_FD_PR__NFET_01V8 L=2 W=8 NF=2 AD='INT((NF+1)/2)*W/NF*0.29' AS='INT((NF+2)/2)*W/NF*0.29' PD='2*INT((NF+1)/2)*(W/NF+0.29)'
+ PS='2*INT((NF+2)/2)*(W/NF+0.29)' NRD='0.29/W' NRS='0.29/W' SA=0 SB=0 SD=0 MULT=1 M=1
*--------END___XMNCAP2->SKY130_FD_PR__NFET_01V8
*--------BEGIN_XMP1->SKY130_FD_PR__PFET_01V8_LVT
XMP1 NET15 MP21CG MP20D VDD  SKY130_FD_PR__PFET_01V8_LVT L=0.35 W=0.6 NF=1 AD='INT((NF+1)/2)*W/NF*0.29' AS='INT((NF+2)/2)*W/NF*0.29'
+ PD='2*INT((NF+1)/2)*(W/NF+0.29)' PS='2*INT((NF+2)/2)*(W/NF+0.29)' NRD='0.29/W' NRS='0.29/W' SA=0 SB=0 SD=0 MULT=1 M=1
*--------END___XMP1->SKY130_FD_PR__PFET_01V8_LVT
*--------BEGIN_XMP2->SKY130_FD_PR__PFET_01V8_LVT
XMP2 NET16 MP21CG NET15 VDD  SKY130_FD_PR__PFET_01V8_LVT L=0.35 W=0.6 NF=1 AD='INT((NF+1)/2)*W/NF*0.29' AS='INT((NF+2)/2)*W/NF*0.29'
+ PD='2*INT((NF+1)/2)*(W/NF+0.29)' PS='2*INT((NF+2)/2)*(W/NF+0.29)' NRD='0.29/W' NRS='0.29/W' SA=0 SB=0 SD=0 MULT=1 M=1
*--------END___XMP2->SKY130_FD_PR__PFET_01V8_LVT
*--------BEGIN_XMP3->SKY130_FD_PR__PFET_01V8_LVT
XMP3 NET17 MP21CG NET16 VDD  SKY130_FD_PR__PFET_01V8_LVT L=0.35 W=0.6 NF=1 AD='INT((NF+1)/2)*W/NF*0.29' AS='INT((NF+2)/2)*W/NF*0.29'
+ PD='2*INT((NF+1)/2)*(W/NF+0.29)' PS='2*INT((NF+2)/2)*(W/NF+0.29)' NRD='0.29/W' NRS='0.29/W' SA=0 SB=0 SD=0 MULT=1 M=1
*--------END___XMP3->SKY130_FD_PR__PFET_01V8_LVT
*--------BEGIN_XMP4->SKY130_FD_PR__PFET_01V8_LVT
XMP4 NET18 MP21CG NET17 VDD  SKY130_FD_PR__PFET_01V8_LVT L=0.35 W=0.6 NF=1 AD='INT((NF+1)/2)*W/NF*0.29' AS='INT((NF+2)/2)*W/NF*0.29'
+ PD='2*INT((NF+1)/2)*(W/NF+0.29)' PS='2*INT((NF+2)/2)*(W/NF+0.29)' NRD='0.29/W' NRS='0.29/W' SA=0 SB=0 SD=0 MULT=1 M=1
*--------END___XMP4->SKY130_FD_PR__PFET_01V8_LVT
*--------BEGIN_XMP5->SKY130_FD_PR__PFET_01V8_LVT
XMP5 MP21CG MP21CG NET18 VDD  SKY130_FD_PR__PFET_01V8_LVT L=0.35 W=0.6 NF=1 AD='INT((NF+1)/2)*W/NF*0.29' AS='INT((NF+2)/2)*W/NF*0.29'
+ PD='2*INT((NF+1)/2)*(W/NF+0.29)' PS='2*INT((NF+2)/2)*(W/NF+0.29)' NRD='0.29/W' NRS='0.29/W' SA=0 SB=0 SD=0 MULT=1 M=1
*--------END___XMP5->SKY130_FD_PR__PFET_01V8_LVT
*--------BEGIN_XMP21PC->SKY130_FD_PR__PFET_01V8_LVT
XMP21PC MN1D MP21CG MP21PD VDD  SKY130_FD_PR__PFET_01V8_LVT L=0.35 W=0.6 NF=1 AD='INT((NF+1)/2)*W/NF*0.29' AS='INT((NF+2)/2)*W/NF*0.29'
+ PD='2*INT((NF+1)/2)*(W/NF+0.29)' PS='2*INT((NF+2)/2)*(W/NF+0.29)' NRD='0.29/W' NRS='0.29/W' SA=0 SB=0 SD=0 MULT=1 M=1
*--------END___XMP21PC->SKY130_FD_PR__PFET_01V8_LVT
*--------BEGIN_XMP21NC->SKY130_FD_PR__PFET_01V8_LVT
XMP21NC NET3 MP21CG MP21ND VDD  SKY130_FD_PR__PFET_01V8_LVT L=0.35 W=0.6 NF=1 AD='INT((NF+1)/2)*W/NF*0.29' AS='INT((NF+2)/2)*W/NF*0.29'
+ PD='2*INT((NF+1)/2)*(W/NF+0.29)' PS='2*INT((NF+2)/2)*(W/NF+0.29)' NRD='0.29/W' NRS='0.29/W' SA=0 SB=0 SD=0 MULT=1 M=1
*--------END___XMP21NC->SKY130_FD_PR__PFET_01V8_LVT
.end
