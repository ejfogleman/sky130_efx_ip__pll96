** sch_path: /home/ejf/Projects/sky130_efx_ip__pll96/xschem/tb_efx_pll96_lpf.sch

* Copyright (c) Eric Fogleman 2025
* SPDX-License-Identifier: Apache-2.0

**.subckt tb_efx_pll96_lpf
V38 csc GND {VCSC}
V_VDD_VCO vdd GND {VDD}
.save i(v_vdd_vco)
xlpf vdd vc GND csc rsc[0] rsc[1] vc2 efx_pll96_lpf
V_VC vc GND {VC} AC=1
.save i(v_vc)
V1 rsc[1] GND {VRSC1}
V3 rsc[0] GND {VRSC0}
* noconn vc2
**** begin user architecture code

* ejf_pfd test
.lib ~/.ciel/sky130A/libs.tech/combined/sky130.lib.spice tt
.option temp=27
.param VDD=1.8
.param VCSC=0
.param VRSC1=1.8
.param VRSC0=1.8
.param VC=0.9

* Run transient
* default reltol=1e-3 vntol=1e-6 abstol=1e-12
.options  reltol=1e-4 vntol=1e-7 abstol=1e-13
.control
   save all
   ac dec 10 1k 1g
   let i_mag = mag(i(v_vc))
   meas ac i_at_1k find i_mag at=1k
   print i_at_1k/6.283/1e3
   meas ac i_at_100meg find i_mag at=100meg
   print i_at_100meg/6.283/100e6
   write tb_efx_pll96_lpf.raw
.endc
.end

**** end user architecture code
**.ends

* expanding   symbol:  efx_pll96_lpf.sym # of pins=7
** sym_path: /home/ejf/Projects/sky130_efx_ip__pll96/xschem/efx_pll96_lpf.sym
** sch_path: /home/ejf/Projects/sky130_efx_ip__pll96/xschem/efx_pll96_lpf.sch
.subckt efx_pll96_lpf vdd vc gnd csc rsc[0] rsc[1] vc2
*.iopin vc
*.iopin vdd
*.iopin gnd
*.ipin csc
*.ipin rsc[0]
*.ipin rsc[1]
*.opin vc2
XR7[5] vdd vdd vdd sky130_fd_pr__res_high_po_0p35 L=5.58 mult=1 m=1
XR7[4] vdd vdd vdd sky130_fd_pr__res_high_po_0p35 L=5.58 mult=1 m=1
XR7[3] vdd vdd vdd sky130_fd_pr__res_high_po_0p35 L=5.58 mult=1 m=1
XR7[2] vdd vdd vdd sky130_fd_pr__res_high_po_0p35 L=5.58 mult=1 m=1
XR7[1] vdd vdd vdd sky130_fd_pr__res_high_po_0p35 L=5.58 mult=1 m=1
XR7[0] vdd vdd vdd sky130_fd_pr__res_high_po_0p35 L=5.58 mult=1 m=1
x2 vdd csc csc_bb csc_b gnd efx_pll96_dbuf
XM1 net5 csc_bb vc2 gnd sky130_fd_pr__nfet_01v8_lvt L=0.15 W=1.08 nf=1 ad='int((nf+1)/2) * W/nf * 0.29' as='int((nf+2)/2) * W/nf * 0.29'
+ pd='2*int((nf+1)/2) * (W/nf + 0.29)' ps='2*int((nf+2)/2) * (W/nf + 0.29)' nrd='0.29 / W' nrs='0.29 / W' sa=0 sb=0 sd=0 mult=10 m=10
XR1 vc net4 vdd sky130_fd_pr__res_high_po_0p35 L=5.58 mult=1 m=1
XR2 net4 net2 vdd sky130_fd_pr__res_high_po_0p35 L=5.58 mult=1 m=1
XR3 net2 net1 vdd sky130_fd_pr__res_high_po_0p35 L=5.58 mult=1 m=1
XR4 net1 net3 vdd sky130_fd_pr__res_high_po_0p35 L=5.58 mult=1 m=1
XR5 net3 net6 vdd sky130_fd_pr__res_high_po_0p35 L=5.58 mult=1 m=1
XR6 net6 vc2 vdd sky130_fd_pr__res_high_po_0p35 L=5.58 mult=1 m=1
x1[1] vdd rsc[1] rsc_bb[1] rsc_b[1] gnd efx_pll96_dbuf
x1[0] vdd rsc[0] rsc_bb[0] rsc_b[0] gnd efx_pll96_dbuf
**** begin user architecture code

* Copyright (c) Eric Fogleman 2025
* SPDX-License-Identifier: Apache-2.0

**** end user architecture code
* noconn csc_b
* noconn rsc_b[1:0]
xc1b vdd net7 efx_pll96_lpf_unit
xc1a vdd vc efx_pll96_lpf_unit
xc2b[9] vdd net5 efx_pll96_lpf_unit
xc2b[8] vdd net5 efx_pll96_lpf_unit
xc2b[7] vdd net5 efx_pll96_lpf_unit
xc2b[6] vdd net5 efx_pll96_lpf_unit
xc2b[5] vdd net5 efx_pll96_lpf_unit
xc2b[4] vdd net5 efx_pll96_lpf_unit
xc2b[3] vdd net5 efx_pll96_lpf_unit
xc2b[2] vdd net5 efx_pll96_lpf_unit
xc2b[1] vdd net5 efx_pll96_lpf_unit
xc2b[0] vdd net5 efx_pll96_lpf_unit
xc2a[9] vdd vc2 efx_pll96_lpf_unit
xc2a[8] vdd vc2 efx_pll96_lpf_unit
xc2a[7] vdd vc2 efx_pll96_lpf_unit
xc2a[6] vdd vc2 efx_pll96_lpf_unit
xc2a[5] vdd vc2 efx_pll96_lpf_unit
xc2a[4] vdd vc2 efx_pll96_lpf_unit
xc2a[3] vdd vc2 efx_pll96_lpf_unit
xc2a[2] vdd vc2 efx_pll96_lpf_unit
xc2a[1] vdd vc2 efx_pll96_lpf_unit
xc2a[0] vdd vc2 efx_pll96_lpf_unit
XM3 vc2 csc_b net5 vdd sky130_fd_pr__pfet_01v8 L=0.15 W=0.63 nf=1 ad=0.1827 as=0.1827 pd=1.84 ps=1.84 nrd=0.46031746031746
+ nrs=0.46031746031746 sa=0 sb=0 sd=0 mult=10 m=10
XM6 net7 csc_bb vc gnd sky130_fd_pr__nfet_01v8_lvt L=0.15 W=1.08 nf=1 ad='int((nf+1)/2) * W/nf * 0.29' as='int((nf+2)/2) * W/nf * 0.29'
+ pd='2*int((nf+1)/2) * (W/nf + 0.29)' ps='2*int((nf+2)/2) * (W/nf + 0.29)' nrd='0.29 / W' nrs='0.29 / W' sa=0 sb=0 sd=0 mult=1 m=1
XM7 vc csc_b net7 vdd sky130_fd_pr__pfet_01v8 L=0.15 W=0.63 nf=1 ad=0.1827 as=0.1827 pd=1.84 ps=1.84 nrd=0.46031746031746
+ nrs=0.46031746031746 sa=0 sb=0 sd=0 mult=1 m=1
XM2 vc2 rsc_bb[1] net1 gnd sky130_fd_pr__nfet_01v8_lvt L=0.15 W=1.08 nf=1 ad='int((nf+1)/2) * W/nf * 0.29' as='int((nf+2)/2) * W/nf * 0.29'
+ pd='2*int((nf+1)/2) * (W/nf + 0.29)' ps='2*int((nf+2)/2) * (W/nf + 0.29)' nrd='0.29 / W' nrs='0.29 / W' sa=0 sb=0 sd=0 mult=10 m=10
XM8 net1 rsc_b[1] vc2 vdd sky130_fd_pr__pfet_01v8 L=0.15 W=0.63 nf=1 ad=0.1827 as=0.1827 pd=1.84 ps=1.84 nrd=0.46031746031746
+ nrs=0.46031746031746 sa=0 sb=0 sd=0 mult=10 m=10
XM4 vc2 rsc_bb[0] net3 gnd sky130_fd_pr__nfet_01v8_lvt L=0.15 W=1.08 nf=1 ad='int((nf+1)/2) * W/nf * 0.29' as='int((nf+2)/2) * W/nf * 0.29'
+ pd='2*int((nf+1)/2) * (W/nf + 0.29)' ps='2*int((nf+2)/2) * (W/nf + 0.29)' nrd='0.29 / W' nrs='0.29 / W' sa=0 sb=0 sd=0 mult=10 m=10
XM5 net3 rsc_b[0] vc2 vdd sky130_fd_pr__pfet_01v8 L=0.15 W=0.63 nf=1 ad=0.1827 as=0.1827 pd=1.84 ps=1.84 nrd=0.46031746031746
+ nrs=0.46031746031746 sa=0 sb=0 sd=0 mult=10 m=10
.ends

* expanding   symbol:  efx_pll96_dbuf.sym # of pins=5
** sym_path: /home/ejf/Projects/sky130_efx_ip__pll96/xschem/efx_pll96_dbuf.sym
** sch_path: /home/ejf/Projects/sky130_efx_ip__pll96/xschem/efx_pll96_dbuf.sch
.subckt efx_pll96_dbuf vdd a y y_b gnd
*.ipin a
*.iopin vdd
*.iopin gnd
*.opin y
*.opin y_b
**** begin user architecture code

* Copyright (c) Eric Fogleman 2025
* SPDX-License-Identifier: Apache-2.0

**** end user architecture code
x1 a y_b gnd gnd vdd vdd sky130_efx_lvdig__inv_1
x2 y_b y gnd gnd vdd vdd sky130_efx_lvdig__inv_1
.ends

* expanding   symbol:  efx_pll96_lpf_unit.sym # of pins=2
** sym_path: /home/ejf/Projects/sky130_efx_ip__pll96/xschem/efx_pll96_lpf_unit.sym
** sch_path: /home/ejf/Projects/sky130_efx_ip__pll96/xschem/efx_pll96_lpf_unit.sch
.subckt efx_pll96_lpf_unit vdd vc
*.ipin vc
*.iopin vdd
**** begin user architecture code

* Copyright (c) Eric Fogleman 2026
* SPDX-License-Identifier: Apache-2.0

**** end user architecture code
XCMIM3 vc vdd sky130_fd_pr__cap_mim_m3_1 W=12.96 L=14.40 MF=1 m=1
XCMIM4 vc vdd sky130_fd_pr__cap_mim_m3_2 W=12.96 L=14.40 MF=1 m=1
XMPC vdd vc vdd vdd sky130_fd_pr__pfet_01v8_lvt L=5.4 W=13.32 nf=1 ad=3.8628 as=3.8628 pd=27.22 ps=27.22 nrd=0.0217717717717718
+ nrs=0.0217717717717718 sa=0 sb=0 sd=0 mult=1 m=1
.ends

.GLOBAL GND
.end
